* F-05: .save of an unknown quantity (I is not a probe quantity): parse error with file:line, exit 1
cwsrc1 in wl=1.55e-6 power=1e-3
wg1 in out length=10e-6
.save I(out)
.op
