* B-014: a delay rounded by more than 10 % to the time step gives a warning (once per device, before the
* simulation). Ring round trip L*ng/c = 4e-6 m * 4 / 299792458 m/s = 53.37 fs, rounded to 1 time step
* of 100 fs (+87.4 %). It used to be silent.
* Expected: stderr "Warning (ROOT/WGR): delay 5.33703e-14 s rounded to 1e-13 s (+87.4 %) at the time
* resolution 1e-13 s; use a finer time resolution, e.g. .options timescale=-14" (at 10 fs: 50 fs, -6.3 %),
* exit 0, simulation unchanged: one round trip per 100 fs step, 40 timestamps (#10 to #49). Lossless all-pass
* ring (k = 0.5, t = sqrt(0.75), phi = 2 pi 2.3 L / 1550 nm = 5.8778 rad mod 2 pi): out -> 1 W, r1, r2 ->
* k^2 / |1 - t e^(i phi)|^2 = 0.25 / 0.158318 = 1.5791 W; still ringing at 4.9 ps (t^39 = 0.37 % in field):
* out = 1.00275 W, r1 = 1.5906 W, r2 = 1.5879 W.
vlsrc1 in values=[[1e-12,1,1.55e-6]]
coupler1 in r1 out r2 k=0.5
wgr r2 r1 length=4e-6 neff=2.3 ng=4 att=0
.tran 5e-12
