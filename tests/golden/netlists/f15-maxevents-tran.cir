* F-15 expert option .options maxevents (event cap): the run stops once the optical output ports have
* processed that many pending entries. Lossy all-pass ring of b153-zerotol-lossy-ring-tran.cir at the
* default tolerances: a 1 ps pulse of 1 mW, round trip 10 ps, field x 0.0707 per round trip. Without a
* cap the activity stops after a few round trips (regress/f15-max-events-cli-priority, --max-events 0).
* Expected with maxevents=20: stderr "Warning: .tran stopped at the event cap at <t>: <n> pending entries
* processed (.options maxevents=20)", n >= 20 (the other entries of the same delta cycle are processed
* too); exit 0; the traces end at that time; the stats say "event_cap_reached": true.
vlsrc1 in values=[[0, 1e-3, 1.55e-6], [1e-12, 0, 1.55e-6]]
coupler1 in ring_bl out ring_br kp=0.5
wg_ring ring_br ring_bl length=1e-3 att=200 neff=3 ng=3
probe1 out
.options maxevents=20
.tran
