* B-180: integer literals are 64-bit; one beyond 9223372036854775807 is a parse error (it was clamped to
* 2147483647 silently: net 3000000000 was N2147483647). Here a numeric net name, 2^64.
* Expected: "Parsing error (tests/golden/netlists/b180-int-literal-net-name.cir:6): integer literal
*   18446744073709551616 is out of range (the limit is 9223372036854775807)", then
*   -- while parsing line: "cwsrc1 18446744073709551616 wl=1.55e-6 power=1e-3", exit 1
cwsrc1 18446744073709551616 wl=1.55e-6 power=1e-3
probe1 18446744073709551616
.op
