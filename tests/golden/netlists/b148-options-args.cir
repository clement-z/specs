* B-148: .options with a positional argument (none accepted)
cwsrc1 a wl=1.55e-6 power=1e-3
probe1 a
.options 5
.tran 1e-11
