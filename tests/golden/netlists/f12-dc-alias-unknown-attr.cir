* F-12: .dc ATTR(elem) alias with an unknown attribute: same error as /cwsrc1/Q
* (Unknown attribute for CWSRC1: Q), exit 1
cwsrc1 in wl=1.55e-6 power=1e-3
probe1 in
.dc Q(cwsrc1) 1e-3 4e-3 1e-3
