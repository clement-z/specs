* B-001: FD write merged only with the queue top, so in a multi-wavelength .op a
* stale partial value of one wavelength could pop last and be emitted as the
* converged value. Same netlist as backlog/repro/a1-fd-multilambda-stale.cir.
* Expected (merger: out = (in1+in2)/sqrt2 per wavelength, fields in sqrt(W)):
*   u(1550) = 0.5/sqrt2 = 0.353553 ; v(1550) = 1/sqrt2 = 0.707107
*   m(1550) = o(1550) = (u+v)/sqrt2 = 0.750000 sqrt(W) = 0.5625 W (was 0.25 W)
cwsrc1 a1 wl=1.55e-6 power=0.25
cwsrc2 a2 wl=1.56e-6 power=4
cwsrc3 b1 wl=1.55e-6 power=1
cwsrc4 b2 wl=1.56e-6 power=0.01
mergeru a1 a2 u
mergerv b1 b2 v
mergerm u v m
wg1 m o length=1e-6 neff=2.3 ng=4 att=0
.op
