* F-02: an unknown function in an expression: parse error with file:line, exit 1
.param a=gaussian(1, 0.1)
cwsrc1 in wl=1.55e-6 power=1e-3
probe1 in
.op
