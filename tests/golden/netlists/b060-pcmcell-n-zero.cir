* B-060: n = 0 keeps the error it already had (checked before the new n > 0 rule).
* Expected: PCM Cell needs values for both Emelt and Nstates
cwsrc1 in wl=1.55e-6 power=1e-3
pcmcell1 in out emelt=1e-12 n=0 tc=0.85 ta=0.95
.op
