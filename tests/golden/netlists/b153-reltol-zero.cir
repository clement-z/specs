* B-153: invalid .options value (reltol=0) must be rejected
cwsrc1 a wl=1.55e-6 power=1e-3
wg1 a b length=1e-4
probe1 b
.options reltol=0
.tran 1e-11
