* PD5: a PROBE traces one wavelength per .dc point. cwsrc1 stays at 1550 nm; cwsrc2 is swept from 1541 to
* 1559 nm (never at 1550 nm). Both sources write m at every point (each .dc point is a fresh steady state,
* B-185; before, cwsrc1's unchanged value was not written again after the first point), and in a wavelength
* sweep a probe latches the swept wavelength when its net carries it (PD5 follow-up 2).
*   probe1 (m): cwsrc2's wavelength at every point (1541, 1547, 1553, 1559 nm)
cwsrc1 a wl=1.55e-6 power=1e-3
cwsrc2 b wl=1.541e-6 power=2e-3
merger1 a b m
probe1 m
.dc WL(cwsrc2) 1.541e-6 1.559e-6 6e-9
