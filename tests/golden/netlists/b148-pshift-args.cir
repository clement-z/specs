* B-148: PSHIFT with three positional arguments (at most 2)
cwsrc1 a wl=1.55e-6 power=1e-3
evlsrc1 e values=[[0,1]]
pshift1 a b e 1 2 3
probe1 b
.tran 1e-11
