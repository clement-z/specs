* B-148: MZI with two positional arguments (at most 1)
cwsrc1 a wl=1.55e-6 power=1e-3
evlsrc1 e values=[[0,1]]
mzi1 a c b d e 1 2
probe1 b
.tran 1e-11
