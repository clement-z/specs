* F-15 (PD3): per-wavelength values of a WDM ring circuit, recorded with the build before the SC_METHOD
* conversion (39f1bf9). 3-ring CROW (discover/scout/bench/crow_gen.py 3 --nwl 4 --pulses 2): one source
* writes 4 wavelengths at the same times, so the nets carry several wavelengths per time step and the
* couplers receive them in several delta cycles. The MLPROBE (one value per listed wavelength) must not
* depend on the order of evaluation within a time step; the PD2 time-only queue order (WIP 935f362) changes
* it at 1551.2 nm (4e-5 relative). No plain PROBE: on a net with several wavelengths it shows the last
* write of the time step, whose wavelength depends on that order. All 4 wavelengths are listed (an unlisted
* one prints a line per event); 0.4 ns keeps the case small.
VLSRC1 in values=[[0,0.001,1.55120301459e-06],[0,0.001,1.55040079748e-06],[0,0.001,1.54959940969e-06],[0,0.001,1.54879884993e-06],[1e-09,0,1.55120301459e-06],[1e-09,0,1.55040079748e-06],[1e-09,0,1.54959940969e-06],[1e-09,0,1.54879884993e-06],[2e-09,0.001,1.55120301459e-06],[2e-09,0.001,1.55040079748e-06],[2e-09,0.001,1.54959940969e-06],[2e-09,0.001,1.54879884993e-06],[3e-09,0,1.55120301459e-06],[3e-09,0,1.55040079748e-06],[3e-09,0,1.54959940969e-06],[3e-09,0,1.54879884993e-06]]
COUPLER0 in r1b_out through r1a_in kp=0.15
COUPLER1 r1a_out r2b_out r1b_in r2a_in kp=0.15
COUPLER2 r2a_out r3b_out r2b_in r3a_in kp=0.15
COUPLER3 r3a_out add r3b_in drop kp=0.15
WG1a r1a_in r1a_out L=3.96409238e-05 att=2 neff=2.2 ng=4.3
WG1b r1b_in r1b_out L=4.0447228e-05 att=2 neff=2.2 ng=4.3
WG2a r2a_in r2a_out L=3.3531679e-05 att=2 neff=2.2 ng=4.3
WG2b r2b_in r2b_out L=2.93772817e-05 att=2 neff=2.2 ng=4.3
WG3a r3a_in r3a_out L=2.77391339e-05 att=2 neff=2.2 ng=4.3
WG3b r3b_in r3b_out L=3.33566726e-05 att=2 neff=2.2 ng=4.3
MLPROBE_DROP drop wl=[1.55120301459e-06, 1.55040079748e-06, 1.54959940969e-06, 1.54879884993e-06]
.options abstol=1e-08 reltol=0.0001 timescale=-13
.tran 4e-10
