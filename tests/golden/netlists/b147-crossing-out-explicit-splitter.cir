* B-147 regression (repro: backlog/repro/v7-xing-v4.cir): crossing output c explicitly
* bidirectional, read only by a unidirectional splitter. Correct before the fix; B-147 alone
* (outputs as writers, without B-144) broke it (z1 = 0): a uni writer took slot :1 while the
* splitter read :0.
* Slots: crossing1 is the first writer of c: c:0; splitter1 (uni reader, 1 writer) reads c:0.
* Since B-159 the crossing is a CrossingBi (c is bidirectional) and a, b, d become
* bidirectional: crossing1 (created first, elaborating c) writes a:0, b:0, d:0 and reads
* a:1, b:1, d:1; cwsrc1 and cwsrc2 (second writers) write a:1 and b:1.
* Expected, crossing model of B-032 with the defaults: t = 1, x = 0 (out1 = in1, out2 = in2,
* and backwards):
*   a:1 = b:1 = 1 mW at 0 (sources); a:0 = b:0 = 0 (nothing comes back on c:1, d:1)
*   c:0 = 1 mW at 0; c:1 = 0; d:0 = 1 mW at 0; d:1 = 0
*   z1 = z2 = 0.5 mW at 0 (splitter: ratio 0.5, field factor sqrt(0.5))
cwsrc1 a wl=1.55e-6 power=1e-3
cwsrc2 b wl=1.55e-6 power=1e-3
crossing1 a b c& d
splitter1 c z1 z2
.op
