* PF03c: regress/spar-ring-tran with delay_per="output" (the device before PF03b): one delay per output, the
* group delay of the largest path into it (add->out for out, in->drop for drop at 1.55 um), so out leaves
* with the drop path's delay; --vci prints the device parameters
vlsrc1 in values=[[0, 0, 1.55e-6], [1e-12, 1, 1.55e-6], [20e-12, 0, 1.55e-6]]
spar1 in add out drop file="../../sparam/data/add_drop_ring.sparam" delay_per="output"
.options timescale=-15
.save out drop
.tran 40e-12
