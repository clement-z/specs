* B-147 regression (repro: backlog/repro/v7-xing-v5.cir): same circuit as
* b147-crossing-out-explicit-splitter with the splitter listed, and created, first: the
* splitter binds c (as a reader, 0 writers: c:0) before the crossing writes it (first
* writer: c:0). Correct before the fix; B-147 alone broke it (z1 = 0).
* Since B-159 the crossing is a CrossingBi: created second (bidir backlog of c), it is still
* the first writer of c (c:0, it reads c:1) and of a, b, d, which it makes bidirectional
* (a:0, b:0, d:0; it reads a:1, b:1, d:1); cwsrc1 and cwsrc2 write a:1 and b:1.
* Expected, crossing model of B-032 with the defaults: t = 1, x = 0 (out1 = in1, out2 = in2,
* and backwards):
*   a:1 = b:1 = 1 mW at 0 (sources); a:0 = b:0 = 0 (nothing comes back on c:1, d:1)
*   c:0 = 1 mW at 0; c:1 = 0; d:0 = 1 mW at 0; d:1 = 0
*   z1 = z2 = 0.5 mW at 0 (splitter: ratio 0.5, field factor sqrt(0.5))
splitter1 c z1 z2
cwsrc1 a wl=1.55e-6 power=1e-3
cwsrc2 b wl=1.55e-6 power=1e-3
crossing1 a b c& d
.op
