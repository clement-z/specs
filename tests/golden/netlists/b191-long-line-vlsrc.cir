* B-191: a netlist line longer than flex's buffer (16 KB) parses: a VLSRC with 2000 inline values (one
* line of 55 KB) failed with "input buffer overflow, can't enlarge buffer because scanner uses REJECT"
* (exit 2). 1 mW at even multiples of 10 ps, 2 mW at odd ones, until 19.99 ns. The values= list is
* ", ".join("[%de-12, %s, 1.55e-6]" % (10 * i, "1e-3" if i % 2 == 0 else "2e-3") for i in range(2000))
vlsrc1 in values=[[0e-12, 1e-3, 1.55e-6], [10e-12, 2e-3, 1.55e-6], [20e-12, 1e-3, 1.55e-6], [30e-12, 2e-3, 1.55e-6], [40e-12, 1e-3, 1.55e-6], [50e-12, 2e-3, 1.55e-6], [60e-12, 1e-3, 1.55e-6], [70e-12, 2e-3, 1.55e-6], [80e-12, 1e-3, 1.55e-6], [90e-12, 2e-3, 1.55e-6], [100e-12, 1e-3, 1.55e-6], [110e-12, 2e-3, 1.55e-6], [120e-12, 1e-3, 1.55e-6], [130e-12, 2e-3, 1.55e-6], [140e-12, 1e-3, 1.55e-6], [150e-12, 2e-3, 1.55e-6], [160e-12, 1e-3, 1.55e-6], [170e-12, 2e-3, 1.55e-6], [180e-12, 1e-3, 1.55e-6], [190e-12, 2e-3, 1.55e-6], [200e-12, 1e-3, 1.55e-6], [210e-12, 2e-3, 1.55e-6], [220e-12, 1e-3, 1.55e-6], [230e-12, 2e-3, 1.55e-6], [240e-12, 1e-3, 1.55e-6], [250e-12, 2e-3, 1.55e-6], [260e-12, 1e-3, 1.55e-6], [270e-12, 2e-3, 1.55e-6], [280e-12, 1e-3, 1.55e-6], [290e-12, 2e-3, 1.55e-6], [300e-12, 1e-3, 1.55e-6], [310e-12, 2e-3, 1.55e-6], [320e-12, 1e-3, 1.55e-6], [330e-12, 2e-3, 1.55e-6], [340e-12, 1e-3, 1.55e-6], [350e-12, 2e-3, 1.55e-6], [360e-12, 1e-3, 1.55e-6], [370e-12, 2e-3, 1.55e-6], [380e-12, 1e-3, 1.55e-6], [390e-12, 2e-3, 1.55e-6], [400e-12, 1e-3, 1.55e-6], [410e-12, 2e-3, 1.55e-6], [420e-12, 1e-3, 1.55e-6], [430e-12, 2e-3, 1.55e-6], [440e-12, 1e-3, 1.55e-6], [450e-12, 2e-3, 1.55e-6], [460e-12, 1e-3, 1.55e-6], [470e-12, 2e-3, 1.55e-6], [480e-12, 1e-3, 1.55e-6], [490e-12, 2e-3, 1.55e-6], [500e-12, 1e-3, 1.55e-6], [510e-12, 2e-3, 1.55e-6], [520e-12, 1e-3, 1.55e-6], [530e-12, 2e-3, 1.55e-6], [540e-12, 1e-3, 1.55e-6], [550e-12, 2e-3, 1.55e-6], [560e-12, 1e-3, 1.55e-6], [570e-12, 2e-3, 1.55e-6], [580e-12, 1e-3, 1.55e-6], [590e-12, 2e-3, 1.55e-6], [600e-12, 1e-3, 1.55e-6], [610e-12, 2e-3, 1.55e-6], [620e-12, 1e-3, 1.55e-6], [630e-12, 2e-3, 1.55e-6], [640e-12, 1e-3, 1.55e-6], [650e-12, 2e-3, 1.55e-6], [660e-12, 1e-3, 1.55e-6], [670e-12, 2e-3, 1.55e-6], [680e-12, 1e-3, 1.55e-6], [690e-12, 2e-3, 1.55e-6], [700e-12, 1e-3, 1.55e-6], [710e-12, 2e-3, 1.55e-6], [720e-12, 1e-3, 1.55e-6], [730e-12, 2e-3, 1.55e-6], [740e-12, 1e-3, 1.55e-6], [750e-12, 2e-3, 1.55e-6], [760e-12, 1e-3, 1.55e-6], [770e-12, 2e-3, 1.55e-6], [780e-12, 1e-3, 1.55e-6], [790e-12, 2e-3, 1.55e-6], [800e-12, 1e-3, 1.55e-6], [810e-12, 2e-3, 1.55e-6], [820e-12, 1e-3, 1.55e-6], [830e-12, 2e-3, 1.55e-6], [840e-12, 1e-3, 1.55e-6], [850e-12, 2e-3, 1.55e-6], [860e-12, 1e-3, 1.55e-6], [870e-12, 2e-3, 1.55e-6], [880e-12, 1e-3, 1.55e-6], [890e-12, 2e-3, 1.55e-6], [900e-12, 1e-3, 1.55e-6], [910e-12, 2e-3, 1.55e-6], [920e-12, 1e-3, 1.55e-6], [930e-12, 2e-3, 1.55e-6], [940e-12, 1e-3, 1.55e-6], [950e-12, 2e-3, 1.55e-6], [960e-12, 1e-3, 1.55e-6], [970e-12, 2e-3, 1.55e-6], [980e-12, 1e-3, 1.55e-6], [990e-12, 2e-3, 1.55e-6], [1000e-12, 1e-3, 1.55e-6], [1010e-12, 2e-3, 1.55e-6], [1020e-12, 1e-3, 1.55e-6], [1030e-12, 2e-3, 1.55e-6], [1040e-12, 1e-3, 1.55e-6], [1050e-12, 2e-3, 1.55e-6], [1060e-12, 1e-3, 1.55e-6], [1070e-12, 2e-3, 1.55e-6], [1080e-12, 1e-3, 1.55e-6], [1090e-12, 2e-3, 1.55e-6], [1100e-12, 1e-3, 1.55e-6], [1110e-12, 2e-3, 1.55e-6], [1120e-12, 1e-3, 1.55e-6], [1130e-12, 2e-3, 1.55e-6], [1140e-12, 1e-3, 1.55e-6], [1150e-12, 2e-3, 1.55e-6], [1160e-12, 1e-3, 1.55e-6], [1170e-12, 2e-3, 1.55e-6], [1180e-12, 1e-3, 1.55e-6], [1190e-12, 2e-3, 1.55e-6], [1200e-12, 1e-3, 1.55e-6], [1210e-12, 2e-3, 1.55e-6], [1220e-12, 1e-3, 1.55e-6], [1230e-12, 2e-3, 1.55e-6], [1240e-12, 1e-3, 1.55e-6], [1250e-12, 2e-3, 1.55e-6], [1260e-12, 1e-3, 1.55e-6], [1270e-12, 2e-3, 1.55e-6], [1280e-12, 1e-3, 1.55e-6], [1290e-12, 2e-3, 1.55e-6], [1300e-12, 1e-3, 1.55e-6], [1310e-12, 2e-3, 1.55e-6], [1320e-12, 1e-3, 1.55e-6], [1330e-12, 2e-3, 1.55e-6], [1340e-12, 1e-3, 1.55e-6], [1350e-12, 2e-3, 1.55e-6], [1360e-12, 1e-3, 1.55e-6], [1370e-12, 2e-3, 1.55e-6], [1380e-12, 1e-3, 1.55e-6], [1390e-12, 2e-3, 1.55e-6], [1400e-12, 1e-3, 1.55e-6], [1410e-12, 2e-3, 1.55e-6], [1420e-12, 1e-3, 1.55e-6], [1430e-12, 2e-3, 1.55e-6], [1440e-12, 1e-3, 1.55e-6], [1450e-12, 2e-3, 1.55e-6], [1460e-12, 1e-3, 1.55e-6], [1470e-12, 2e-3, 1.55e-6], [1480e-12, 1e-3, 1.55e-6], [1490e-12, 2e-3, 1.55e-6], [1500e-12, 1e-3, 1.55e-6], [1510e-12, 2e-3, 1.55e-6], [1520e-12, 1e-3, 1.55e-6], [1530e-12, 2e-3, 1.55e-6], [1540e-12, 1e-3, 1.55e-6], [1550e-12, 2e-3, 1.55e-6], [1560e-12, 1e-3, 1.55e-6], [1570e-12, 2e-3, 1.55e-6], [1580e-12, 1e-3, 1.55e-6], [1590e-12, 2e-3, 1.55e-6], [1600e-12, 1e-3, 1.55e-6], [1610e-12, 2e-3, 1.55e-6], [1620e-12, 1e-3, 1.55e-6], [1630e-12, 2e-3, 1.55e-6], [1640e-12, 1e-3, 1.55e-6], [1650e-12, 2e-3, 1.55e-6], [1660e-12, 1e-3, 1.55e-6], [1670e-12, 2e-3, 1.55e-6], [1680e-12, 1e-3, 1.55e-6], [1690e-12, 2e-3, 1.55e-6], [1700e-12, 1e-3, 1.55e-6], [1710e-12, 2e-3, 1.55e-6], [1720e-12, 1e-3, 1.55e-6], [1730e-12, 2e-3, 1.55e-6], [1740e-12, 1e-3, 1.55e-6], [1750e-12, 2e-3, 1.55e-6], [1760e-12, 1e-3, 1.55e-6], [1770e-12, 2e-3, 1.55e-6], [1780e-12, 1e-3, 1.55e-6], [1790e-12, 2e-3, 1.55e-6], [1800e-12, 1e-3, 1.55e-6], [1810e-12, 2e-3, 1.55e-6], [1820e-12, 1e-3, 1.55e-6], [1830e-12, 2e-3, 1.55e-6], [1840e-12, 1e-3, 1.55e-6], [1850e-12, 2e-3, 1.55e-6], [1860e-12, 1e-3, 1.55e-6], [1870e-12, 2e-3, 1.55e-6], [1880e-12, 1e-3, 1.55e-6], [1890e-12, 2e-3, 1.55e-6], [1900e-12, 1e-3, 1.55e-6], [1910e-12, 2e-3, 1.55e-6], [1920e-12, 1e-3, 1.55e-6], [1930e-12, 2e-3, 1.55e-6], [1940e-12, 1e-3, 1.55e-6], [1950e-12, 2e-3, 1.55e-6], [1960e-12, 1e-3, 1.55e-6], [1970e-12, 2e-3, 1.55e-6], [1980e-12, 1e-3, 1.55e-6], [1990e-12, 2e-3, 1.55e-6], [2000e-12, 1e-3, 1.55e-6], [2010e-12, 2e-3, 1.55e-6], [2020e-12, 1e-3, 1.55e-6], [2030e-12, 2e-3, 1.55e-6], [2040e-12, 1e-3, 1.55e-6], [2050e-12, 2e-3, 1.55e-6], [2060e-12, 1e-3, 1.55e-6], [2070e-12, 2e-3, 1.55e-6], [2080e-12, 1e-3, 1.55e-6], [2090e-12, 2e-3, 1.55e-6], [2100e-12, 1e-3, 1.55e-6], [2110e-12, 2e-3, 1.55e-6], [2120e-12, 1e-3, 1.55e-6], [2130e-12, 2e-3, 1.55e-6], [2140e-12, 1e-3, 1.55e-6], [2150e-12, 2e-3, 1.55e-6], [2160e-12, 1e-3, 1.55e-6], [2170e-12, 2e-3, 1.55e-6], [2180e-12, 1e-3, 1.55e-6], [2190e-12, 2e-3, 1.55e-6], [2200e-12, 1e-3, 1.55e-6], [2210e-12, 2e-3, 1.55e-6], [2220e-12, 1e-3, 1.55e-6], [2230e-12, 2e-3, 1.55e-6], [2240e-12, 1e-3, 1.55e-6], [2250e-12, 2e-3, 1.55e-6], [2260e-12, 1e-3, 1.55e-6], [2270e-12, 2e-3, 1.55e-6], [2280e-12, 1e-3, 1.55e-6], [2290e-12, 2e-3, 1.55e-6], [2300e-12, 1e-3, 1.55e-6], [2310e-12, 2e-3, 1.55e-6], [2320e-12, 1e-3, 1.55e-6], [2330e-12, 2e-3, 1.55e-6], [2340e-12, 1e-3, 1.55e-6], [2350e-12, 2e-3, 1.55e-6], [2360e-12, 1e-3, 1.55e-6], [2370e-12, 2e-3, 1.55e-6], [2380e-12, 1e-3, 1.55e-6], [2390e-12, 2e-3, 1.55e-6], [2400e-12, 1e-3, 1.55e-6], [2410e-12, 2e-3, 1.55e-6], [2420e-12, 1e-3, 1.55e-6], [2430e-12, 2e-3, 1.55e-6], [2440e-12, 1e-3, 1.55e-6], [2450e-12, 2e-3, 1.55e-6], [2460e-12, 1e-3, 1.55e-6], [2470e-12, 2e-3, 1.55e-6], [2480e-12, 1e-3, 1.55e-6], [2490e-12, 2e-3, 1.55e-6], [2500e-12, 1e-3, 1.55e-6], [2510e-12, 2e-3, 1.55e-6], [2520e-12, 1e-3, 1.55e-6], [2530e-12, 2e-3, 1.55e-6], [2540e-12, 1e-3, 1.55e-6], [2550e-12, 2e-3, 1.55e-6], [2560e-12, 1e-3, 1.55e-6], [2570e-12, 2e-3, 1.55e-6], [2580e-12, 1e-3, 1.55e-6], [2590e-12, 2e-3, 1.55e-6], [2600e-12, 1e-3, 1.55e-6], [2610e-12, 2e-3, 1.55e-6], [2620e-12, 1e-3, 1.55e-6], [2630e-12, 2e-3, 1.55e-6], [2640e-12, 1e-3, 1.55e-6], [2650e-12, 2e-3, 1.55e-6], [2660e-12, 1e-3, 1.55e-6], [2670e-12, 2e-3, 1.55e-6], [2680e-12, 1e-3, 1.55e-6], [2690e-12, 2e-3, 1.55e-6], [2700e-12, 1e-3, 1.55e-6], [2710e-12, 2e-3, 1.55e-6], [2720e-12, 1e-3, 1.55e-6], [2730e-12, 2e-3, 1.55e-6], [2740e-12, 1e-3, 1.55e-6], [2750e-12, 2e-3, 1.55e-6], [2760e-12, 1e-3, 1.55e-6], [2770e-12, 2e-3, 1.55e-6], [2780e-12, 1e-3, 1.55e-6], [2790e-12, 2e-3, 1.55e-6], [2800e-12, 1e-3, 1.55e-6], [2810e-12, 2e-3, 1.55e-6], [2820e-12, 1e-3, 1.55e-6], [2830e-12, 2e-3, 1.55e-6], [2840e-12, 1e-3, 1.55e-6], [2850e-12, 2e-3, 1.55e-6], [2860e-12, 1e-3, 1.55e-6], [2870e-12, 2e-3, 1.55e-6], [2880e-12, 1e-3, 1.55e-6], [2890e-12, 2e-3, 1.55e-6], [2900e-12, 1e-3, 1.55e-6], [2910e-12, 2e-3, 1.55e-6], [2920e-12, 1e-3, 1.55e-6], [2930e-12, 2e-3, 1.55e-6], [2940e-12, 1e-3, 1.55e-6], [2950e-12, 2e-3, 1.55e-6], [2960e-12, 1e-3, 1.55e-6], [2970e-12, 2e-3, 1.55e-6], [2980e-12, 1e-3, 1.55e-6], [2990e-12, 2e-3, 1.55e-6], [3000e-12, 1e-3, 1.55e-6], [3010e-12, 2e-3, 1.55e-6], [3020e-12, 1e-3, 1.55e-6], [3030e-12, 2e-3, 1.55e-6], [3040e-12, 1e-3, 1.55e-6], [3050e-12, 2e-3, 1.55e-6], [3060e-12, 1e-3, 1.55e-6], [3070e-12, 2e-3, 1.55e-6], [3080e-12, 1e-3, 1.55e-6], [3090e-12, 2e-3, 1.55e-6], [3100e-12, 1e-3, 1.55e-6], [3110e-12, 2e-3, 1.55e-6], [3120e-12, 1e-3, 1.55e-6], [3130e-12, 2e-3, 1.55e-6], [3140e-12, 1e-3, 1.55e-6], [3150e-12, 2e-3, 1.55e-6], [3160e-12, 1e-3, 1.55e-6], [3170e-12, 2e-3, 1.55e-6], [3180e-12, 1e-3, 1.55e-6], [3190e-12, 2e-3, 1.55e-6], [3200e-12, 1e-3, 1.55e-6], [3210e-12, 2e-3, 1.55e-6], [3220e-12, 1e-3, 1.55e-6], [3230e-12, 2e-3, 1.55e-6], [3240e-12, 1e-3, 1.55e-6], [3250e-12, 2e-3, 1.55e-6], [3260e-12, 1e-3, 1.55e-6], [3270e-12, 2e-3, 1.55e-6], [3280e-12, 1e-3, 1.55e-6], [3290e-12, 2e-3, 1.55e-6], [3300e-12, 1e-3, 1.55e-6], [3310e-12, 2e-3, 1.55e-6], [3320e-12, 1e-3, 1.55e-6], [3330e-12, 2e-3, 1.55e-6], [3340e-12, 1e-3, 1.55e-6], [3350e-12, 2e-3, 1.55e-6], [3360e-12, 1e-3, 1.55e-6], [3370e-12, 2e-3, 1.55e-6], [3380e-12, 1e-3, 1.55e-6], [3390e-12, 2e-3, 1.55e-6], [3400e-12, 1e-3, 1.55e-6], [3410e-12, 2e-3, 1.55e-6], [3420e-12, 1e-3, 1.55e-6], [3430e-12, 2e-3, 1.55e-6], [3440e-12, 1e-3, 1.55e-6], [3450e-12, 2e-3, 1.55e-6], [3460e-12, 1e-3, 1.55e-6], [3470e-12, 2e-3, 1.55e-6], [3480e-12, 1e-3, 1.55e-6], [3490e-12, 2e-3, 1.55e-6], [3500e-12, 1e-3, 1.55e-6], [3510e-12, 2e-3, 1.55e-6], [3520e-12, 1e-3, 1.55e-6], [3530e-12, 2e-3, 1.55e-6], [3540e-12, 1e-3, 1.55e-6], [3550e-12, 2e-3, 1.55e-6], [3560e-12, 1e-3, 1.55e-6], [3570e-12, 2e-3, 1.55e-6], [3580e-12, 1e-3, 1.55e-6], [3590e-12, 2e-3, 1.55e-6], [3600e-12, 1e-3, 1.55e-6], [3610e-12, 2e-3, 1.55e-6], [3620e-12, 1e-3, 1.55e-6], [3630e-12, 2e-3, 1.55e-6], [3640e-12, 1e-3, 1.55e-6], [3650e-12, 2e-3, 1.55e-6], [3660e-12, 1e-3, 1.55e-6], [3670e-12, 2e-3, 1.55e-6], [3680e-12, 1e-3, 1.55e-6], [3690e-12, 2e-3, 1.55e-6], [3700e-12, 1e-3, 1.55e-6], [3710e-12, 2e-3, 1.55e-6], [3720e-12, 1e-3, 1.55e-6], [3730e-12, 2e-3, 1.55e-6], [3740e-12, 1e-3, 1.55e-6], [3750e-12, 2e-3, 1.55e-6], [3760e-12, 1e-3, 1.55e-6], [3770e-12, 2e-3, 1.55e-6], [3780e-12, 1e-3, 1.55e-6], [3790e-12, 2e-3, 1.55e-6], [3800e-12, 1e-3, 1.55e-6], [3810e-12, 2e-3, 1.55e-6], [3820e-12, 1e-3, 1.55e-6], [3830e-12, 2e-3, 1.55e-6], [3840e-12, 1e-3, 1.55e-6], [3850e-12, 2e-3, 1.55e-6], [3860e-12, 1e-3, 1.55e-6], [3870e-12, 2e-3, 1.55e-6], [3880e-12, 1e-3, 1.55e-6], [3890e-12, 2e-3, 1.55e-6], [3900e-12, 1e-3, 1.55e-6], [3910e-12, 2e-3, 1.55e-6], [3920e-12, 1e-3, 1.55e-6], [3930e-12, 2e-3, 1.55e-6], [3940e-12, 1e-3, 1.55e-6], [3950e-12, 2e-3, 1.55e-6], [3960e-12, 1e-3, 1.55e-6], [3970e-12, 2e-3, 1.55e-6], [3980e-12, 1e-3, 1.55e-6], [3990e-12, 2e-3, 1.55e-6], [4000e-12, 1e-3, 1.55e-6], [4010e-12, 2e-3, 1.55e-6], [4020e-12, 1e-3, 1.55e-6], [4030e-12, 2e-3, 1.55e-6], [4040e-12, 1e-3, 1.55e-6], [4050e-12, 2e-3, 1.55e-6], [4060e-12, 1e-3, 1.55e-6], [4070e-12, 2e-3, 1.55e-6], [4080e-12, 1e-3, 1.55e-6], [4090e-12, 2e-3, 1.55e-6], [4100e-12, 1e-3, 1.55e-6], [4110e-12, 2e-3, 1.55e-6], [4120e-12, 1e-3, 1.55e-6], [4130e-12, 2e-3, 1.55e-6], [4140e-12, 1e-3, 1.55e-6], [4150e-12, 2e-3, 1.55e-6], [4160e-12, 1e-3, 1.55e-6], [4170e-12, 2e-3, 1.55e-6], [4180e-12, 1e-3, 1.55e-6], [4190e-12, 2e-3, 1.55e-6], [4200e-12, 1e-3, 1.55e-6], [4210e-12, 2e-3, 1.55e-6], [4220e-12, 1e-3, 1.55e-6], [4230e-12, 2e-3, 1.55e-6], [4240e-12, 1e-3, 1.55e-6], [4250e-12, 2e-3, 1.55e-6], [4260e-12, 1e-3, 1.55e-6], [4270e-12, 2e-3, 1.55e-6], [4280e-12, 1e-3, 1.55e-6], [4290e-12, 2e-3, 1.55e-6], [4300e-12, 1e-3, 1.55e-6], [4310e-12, 2e-3, 1.55e-6], [4320e-12, 1e-3, 1.55e-6], [4330e-12, 2e-3, 1.55e-6], [4340e-12, 1e-3, 1.55e-6], [4350e-12, 2e-3, 1.55e-6], [4360e-12, 1e-3, 1.55e-6], [4370e-12, 2e-3, 1.55e-6], [4380e-12, 1e-3, 1.55e-6], [4390e-12, 2e-3, 1.55e-6], [4400e-12, 1e-3, 1.55e-6], [4410e-12, 2e-3, 1.55e-6], [4420e-12, 1e-3, 1.55e-6], [4430e-12, 2e-3, 1.55e-6], [4440e-12, 1e-3, 1.55e-6], [4450e-12, 2e-3, 1.55e-6], [4460e-12, 1e-3, 1.55e-6], [4470e-12, 2e-3, 1.55e-6], [4480e-12, 1e-3, 1.55e-6], [4490e-12, 2e-3, 1.55e-6], [4500e-12, 1e-3, 1.55e-6], [4510e-12, 2e-3, 1.55e-6], [4520e-12, 1e-3, 1.55e-6], [4530e-12, 2e-3, 1.55e-6], [4540e-12, 1e-3, 1.55e-6], [4550e-12, 2e-3, 1.55e-6], [4560e-12, 1e-3, 1.55e-6], [4570e-12, 2e-3, 1.55e-6], [4580e-12, 1e-3, 1.55e-6], [4590e-12, 2e-3, 1.55e-6], [4600e-12, 1e-3, 1.55e-6], [4610e-12, 2e-3, 1.55e-6], [4620e-12, 1e-3, 1.55e-6], [4630e-12, 2e-3, 1.55e-6], [4640e-12, 1e-3, 1.55e-6], [4650e-12, 2e-3, 1.55e-6], [4660e-12, 1e-3, 1.55e-6], [4670e-12, 2e-3, 1.55e-6], [4680e-12, 1e-3, 1.55e-6], [4690e-12, 2e-3, 1.55e-6], [4700e-12, 1e-3, 1.55e-6], [4710e-12, 2e-3, 1.55e-6], [4720e-12, 1e-3, 1.55e-6], [4730e-12, 2e-3, 1.55e-6], [4740e-12, 1e-3, 1.55e-6], [4750e-12, 2e-3, 1.55e-6], [4760e-12, 1e-3, 1.55e-6], [4770e-12, 2e-3, 1.55e-6], [4780e-12, 1e-3, 1.55e-6], [4790e-12, 2e-3, 1.55e-6], [4800e-12, 1e-3, 1.55e-6], [4810e-12, 2e-3, 1.55e-6], [4820e-12, 1e-3, 1.55e-6], [4830e-12, 2e-3, 1.55e-6], [4840e-12, 1e-3, 1.55e-6], [4850e-12, 2e-3, 1.55e-6], [4860e-12, 1e-3, 1.55e-6], [4870e-12, 2e-3, 1.55e-6], [4880e-12, 1e-3, 1.55e-6], [4890e-12, 2e-3, 1.55e-6], [4900e-12, 1e-3, 1.55e-6], [4910e-12, 2e-3, 1.55e-6], [4920e-12, 1e-3, 1.55e-6], [4930e-12, 2e-3, 1.55e-6], [4940e-12, 1e-3, 1.55e-6], [4950e-12, 2e-3, 1.55e-6], [4960e-12, 1e-3, 1.55e-6], [4970e-12, 2e-3, 1.55e-6], [4980e-12, 1e-3, 1.55e-6], [4990e-12, 2e-3, 1.55e-6], [5000e-12, 1e-3, 1.55e-6], [5010e-12, 2e-3, 1.55e-6], [5020e-12, 1e-3, 1.55e-6], [5030e-12, 2e-3, 1.55e-6], [5040e-12, 1e-3, 1.55e-6], [5050e-12, 2e-3, 1.55e-6], [5060e-12, 1e-3, 1.55e-6], [5070e-12, 2e-3, 1.55e-6], [5080e-12, 1e-3, 1.55e-6], [5090e-12, 2e-3, 1.55e-6], [5100e-12, 1e-3, 1.55e-6], [5110e-12, 2e-3, 1.55e-6], [5120e-12, 1e-3, 1.55e-6], [5130e-12, 2e-3, 1.55e-6], [5140e-12, 1e-3, 1.55e-6], [5150e-12, 2e-3, 1.55e-6], [5160e-12, 1e-3, 1.55e-6], [5170e-12, 2e-3, 1.55e-6], [5180e-12, 1e-3, 1.55e-6], [5190e-12, 2e-3, 1.55e-6], [5200e-12, 1e-3, 1.55e-6], [5210e-12, 2e-3, 1.55e-6], [5220e-12, 1e-3, 1.55e-6], [5230e-12, 2e-3, 1.55e-6], [5240e-12, 1e-3, 1.55e-6], [5250e-12, 2e-3, 1.55e-6], [5260e-12, 1e-3, 1.55e-6], [5270e-12, 2e-3, 1.55e-6], [5280e-12, 1e-3, 1.55e-6], [5290e-12, 2e-3, 1.55e-6], [5300e-12, 1e-3, 1.55e-6], [5310e-12, 2e-3, 1.55e-6], [5320e-12, 1e-3, 1.55e-6], [5330e-12, 2e-3, 1.55e-6], [5340e-12, 1e-3, 1.55e-6], [5350e-12, 2e-3, 1.55e-6], [5360e-12, 1e-3, 1.55e-6], [5370e-12, 2e-3, 1.55e-6], [5380e-12, 1e-3, 1.55e-6], [5390e-12, 2e-3, 1.55e-6], [5400e-12, 1e-3, 1.55e-6], [5410e-12, 2e-3, 1.55e-6], [5420e-12, 1e-3, 1.55e-6], [5430e-12, 2e-3, 1.55e-6], [5440e-12, 1e-3, 1.55e-6], [5450e-12, 2e-3, 1.55e-6], [5460e-12, 1e-3, 1.55e-6], [5470e-12, 2e-3, 1.55e-6], [5480e-12, 1e-3, 1.55e-6], [5490e-12, 2e-3, 1.55e-6], [5500e-12, 1e-3, 1.55e-6], [5510e-12, 2e-3, 1.55e-6], [5520e-12, 1e-3, 1.55e-6], [5530e-12, 2e-3, 1.55e-6], [5540e-12, 1e-3, 1.55e-6], [5550e-12, 2e-3, 1.55e-6], [5560e-12, 1e-3, 1.55e-6], [5570e-12, 2e-3, 1.55e-6], [5580e-12, 1e-3, 1.55e-6], [5590e-12, 2e-3, 1.55e-6], [5600e-12, 1e-3, 1.55e-6], [5610e-12, 2e-3, 1.55e-6], [5620e-12, 1e-3, 1.55e-6], [5630e-12, 2e-3, 1.55e-6], [5640e-12, 1e-3, 1.55e-6], [5650e-12, 2e-3, 1.55e-6], [5660e-12, 1e-3, 1.55e-6], [5670e-12, 2e-3, 1.55e-6], [5680e-12, 1e-3, 1.55e-6], [5690e-12, 2e-3, 1.55e-6], [5700e-12, 1e-3, 1.55e-6], [5710e-12, 2e-3, 1.55e-6], [5720e-12, 1e-3, 1.55e-6], [5730e-12, 2e-3, 1.55e-6], [5740e-12, 1e-3, 1.55e-6], [5750e-12, 2e-3, 1.55e-6], [5760e-12, 1e-3, 1.55e-6], [5770e-12, 2e-3, 1.55e-6], [5780e-12, 1e-3, 1.55e-6], [5790e-12, 2e-3, 1.55e-6], [5800e-12, 1e-3, 1.55e-6], [5810e-12, 2e-3, 1.55e-6], [5820e-12, 1e-3, 1.55e-6], [5830e-12, 2e-3, 1.55e-6], [5840e-12, 1e-3, 1.55e-6], [5850e-12, 2e-3, 1.55e-6], [5860e-12, 1e-3, 1.55e-6], [5870e-12, 2e-3, 1.55e-6], [5880e-12, 1e-3, 1.55e-6], [5890e-12, 2e-3, 1.55e-6], [5900e-12, 1e-3, 1.55e-6], [5910e-12, 2e-3, 1.55e-6], [5920e-12, 1e-3, 1.55e-6], [5930e-12, 2e-3, 1.55e-6], [5940e-12, 1e-3, 1.55e-6], [5950e-12, 2e-3, 1.55e-6], [5960e-12, 1e-3, 1.55e-6], [5970e-12, 2e-3, 1.55e-6], [5980e-12, 1e-3, 1.55e-6], [5990e-12, 2e-3, 1.55e-6], [6000e-12, 1e-3, 1.55e-6], [6010e-12, 2e-3, 1.55e-6], [6020e-12, 1e-3, 1.55e-6], [6030e-12, 2e-3, 1.55e-6], [6040e-12, 1e-3, 1.55e-6], [6050e-12, 2e-3, 1.55e-6], [6060e-12, 1e-3, 1.55e-6], [6070e-12, 2e-3, 1.55e-6], [6080e-12, 1e-3, 1.55e-6], [6090e-12, 2e-3, 1.55e-6], [6100e-12, 1e-3, 1.55e-6], [6110e-12, 2e-3, 1.55e-6], [6120e-12, 1e-3, 1.55e-6], [6130e-12, 2e-3, 1.55e-6], [6140e-12, 1e-3, 1.55e-6], [6150e-12, 2e-3, 1.55e-6], [6160e-12, 1e-3, 1.55e-6], [6170e-12, 2e-3, 1.55e-6], [6180e-12, 1e-3, 1.55e-6], [6190e-12, 2e-3, 1.55e-6], [6200e-12, 1e-3, 1.55e-6], [6210e-12, 2e-3, 1.55e-6], [6220e-12, 1e-3, 1.55e-6], [6230e-12, 2e-3, 1.55e-6], [6240e-12, 1e-3, 1.55e-6], [6250e-12, 2e-3, 1.55e-6], [6260e-12, 1e-3, 1.55e-6], [6270e-12, 2e-3, 1.55e-6], [6280e-12, 1e-3, 1.55e-6], [6290e-12, 2e-3, 1.55e-6], [6300e-12, 1e-3, 1.55e-6], [6310e-12, 2e-3, 1.55e-6], [6320e-12, 1e-3, 1.55e-6], [6330e-12, 2e-3, 1.55e-6], [6340e-12, 1e-3, 1.55e-6], [6350e-12, 2e-3, 1.55e-6], [6360e-12, 1e-3, 1.55e-6], [6370e-12, 2e-3, 1.55e-6], [6380e-12, 1e-3, 1.55e-6], [6390e-12, 2e-3, 1.55e-6], [6400e-12, 1e-3, 1.55e-6], [6410e-12, 2e-3, 1.55e-6], [6420e-12, 1e-3, 1.55e-6], [6430e-12, 2e-3, 1.55e-6], [6440e-12, 1e-3, 1.55e-6], [6450e-12, 2e-3, 1.55e-6], [6460e-12, 1e-3, 1.55e-6], [6470e-12, 2e-3, 1.55e-6], [6480e-12, 1e-3, 1.55e-6], [6490e-12, 2e-3, 1.55e-6], [6500e-12, 1e-3, 1.55e-6], [6510e-12, 2e-3, 1.55e-6], [6520e-12, 1e-3, 1.55e-6], [6530e-12, 2e-3, 1.55e-6], [6540e-12, 1e-3, 1.55e-6], [6550e-12, 2e-3, 1.55e-6], [6560e-12, 1e-3, 1.55e-6], [6570e-12, 2e-3, 1.55e-6], [6580e-12, 1e-3, 1.55e-6], [6590e-12, 2e-3, 1.55e-6], [6600e-12, 1e-3, 1.55e-6], [6610e-12, 2e-3, 1.55e-6], [6620e-12, 1e-3, 1.55e-6], [6630e-12, 2e-3, 1.55e-6], [6640e-12, 1e-3, 1.55e-6], [6650e-12, 2e-3, 1.55e-6], [6660e-12, 1e-3, 1.55e-6], [6670e-12, 2e-3, 1.55e-6], [6680e-12, 1e-3, 1.55e-6], [6690e-12, 2e-3, 1.55e-6], [6700e-12, 1e-3, 1.55e-6], [6710e-12, 2e-3, 1.55e-6], [6720e-12, 1e-3, 1.55e-6], [6730e-12, 2e-3, 1.55e-6], [6740e-12, 1e-3, 1.55e-6], [6750e-12, 2e-3, 1.55e-6], [6760e-12, 1e-3, 1.55e-6], [6770e-12, 2e-3, 1.55e-6], [6780e-12, 1e-3, 1.55e-6], [6790e-12, 2e-3, 1.55e-6], [6800e-12, 1e-3, 1.55e-6], [6810e-12, 2e-3, 1.55e-6], [6820e-12, 1e-3, 1.55e-6], [6830e-12, 2e-3, 1.55e-6], [6840e-12, 1e-3, 1.55e-6], [6850e-12, 2e-3, 1.55e-6], [6860e-12, 1e-3, 1.55e-6], [6870e-12, 2e-3, 1.55e-6], [6880e-12, 1e-3, 1.55e-6], [6890e-12, 2e-3, 1.55e-6], [6900e-12, 1e-3, 1.55e-6], [6910e-12, 2e-3, 1.55e-6], [6920e-12, 1e-3, 1.55e-6], [6930e-12, 2e-3, 1.55e-6], [6940e-12, 1e-3, 1.55e-6], [6950e-12, 2e-3, 1.55e-6], [6960e-12, 1e-3, 1.55e-6], [6970e-12, 2e-3, 1.55e-6], [6980e-12, 1e-3, 1.55e-6], [6990e-12, 2e-3, 1.55e-6], [7000e-12, 1e-3, 1.55e-6], [7010e-12, 2e-3, 1.55e-6], [7020e-12, 1e-3, 1.55e-6], [7030e-12, 2e-3, 1.55e-6], [7040e-12, 1e-3, 1.55e-6], [7050e-12, 2e-3, 1.55e-6], [7060e-12, 1e-3, 1.55e-6], [7070e-12, 2e-3, 1.55e-6], [7080e-12, 1e-3, 1.55e-6], [7090e-12, 2e-3, 1.55e-6], [7100e-12, 1e-3, 1.55e-6], [7110e-12, 2e-3, 1.55e-6], [7120e-12, 1e-3, 1.55e-6], [7130e-12, 2e-3, 1.55e-6], [7140e-12, 1e-3, 1.55e-6], [7150e-12, 2e-3, 1.55e-6], [7160e-12, 1e-3, 1.55e-6], [7170e-12, 2e-3, 1.55e-6], [7180e-12, 1e-3, 1.55e-6], [7190e-12, 2e-3, 1.55e-6], [7200e-12, 1e-3, 1.55e-6], [7210e-12, 2e-3, 1.55e-6], [7220e-12, 1e-3, 1.55e-6], [7230e-12, 2e-3, 1.55e-6], [7240e-12, 1e-3, 1.55e-6], [7250e-12, 2e-3, 1.55e-6], [7260e-12, 1e-3, 1.55e-6], [7270e-12, 2e-3, 1.55e-6], [7280e-12, 1e-3, 1.55e-6], [7290e-12, 2e-3, 1.55e-6], [7300e-12, 1e-3, 1.55e-6], [7310e-12, 2e-3, 1.55e-6], [7320e-12, 1e-3, 1.55e-6], [7330e-12, 2e-3, 1.55e-6], [7340e-12, 1e-3, 1.55e-6], [7350e-12, 2e-3, 1.55e-6], [7360e-12, 1e-3, 1.55e-6], [7370e-12, 2e-3, 1.55e-6], [7380e-12, 1e-3, 1.55e-6], [7390e-12, 2e-3, 1.55e-6], [7400e-12, 1e-3, 1.55e-6], [7410e-12, 2e-3, 1.55e-6], [7420e-12, 1e-3, 1.55e-6], [7430e-12, 2e-3, 1.55e-6], [7440e-12, 1e-3, 1.55e-6], [7450e-12, 2e-3, 1.55e-6], [7460e-12, 1e-3, 1.55e-6], [7470e-12, 2e-3, 1.55e-6], [7480e-12, 1e-3, 1.55e-6], [7490e-12, 2e-3, 1.55e-6], [7500e-12, 1e-3, 1.55e-6], [7510e-12, 2e-3, 1.55e-6], [7520e-12, 1e-3, 1.55e-6], [7530e-12, 2e-3, 1.55e-6], [7540e-12, 1e-3, 1.55e-6], [7550e-12, 2e-3, 1.55e-6], [7560e-12, 1e-3, 1.55e-6], [7570e-12, 2e-3, 1.55e-6], [7580e-12, 1e-3, 1.55e-6], [7590e-12, 2e-3, 1.55e-6], [7600e-12, 1e-3, 1.55e-6], [7610e-12, 2e-3, 1.55e-6], [7620e-12, 1e-3, 1.55e-6], [7630e-12, 2e-3, 1.55e-6], [7640e-12, 1e-3, 1.55e-6], [7650e-12, 2e-3, 1.55e-6], [7660e-12, 1e-3, 1.55e-6], [7670e-12, 2e-3, 1.55e-6], [7680e-12, 1e-3, 1.55e-6], [7690e-12, 2e-3, 1.55e-6], [7700e-12, 1e-3, 1.55e-6], [7710e-12, 2e-3, 1.55e-6], [7720e-12, 1e-3, 1.55e-6], [7730e-12, 2e-3, 1.55e-6], [7740e-12, 1e-3, 1.55e-6], [7750e-12, 2e-3, 1.55e-6], [7760e-12, 1e-3, 1.55e-6], [7770e-12, 2e-3, 1.55e-6], [7780e-12, 1e-3, 1.55e-6], [7790e-12, 2e-3, 1.55e-6], [7800e-12, 1e-3, 1.55e-6], [7810e-12, 2e-3, 1.55e-6], [7820e-12, 1e-3, 1.55e-6], [7830e-12, 2e-3, 1.55e-6], [7840e-12, 1e-3, 1.55e-6], [7850e-12, 2e-3, 1.55e-6], [7860e-12, 1e-3, 1.55e-6], [7870e-12, 2e-3, 1.55e-6], [7880e-12, 1e-3, 1.55e-6], [7890e-12, 2e-3, 1.55e-6], [7900e-12, 1e-3, 1.55e-6], [7910e-12, 2e-3, 1.55e-6], [7920e-12, 1e-3, 1.55e-6], [7930e-12, 2e-3, 1.55e-6], [7940e-12, 1e-3, 1.55e-6], [7950e-12, 2e-3, 1.55e-6], [7960e-12, 1e-3, 1.55e-6], [7970e-12, 2e-3, 1.55e-6], [7980e-12, 1e-3, 1.55e-6], [7990e-12, 2e-3, 1.55e-6], [8000e-12, 1e-3, 1.55e-6], [8010e-12, 2e-3, 1.55e-6], [8020e-12, 1e-3, 1.55e-6], [8030e-12, 2e-3, 1.55e-6], [8040e-12, 1e-3, 1.55e-6], [8050e-12, 2e-3, 1.55e-6], [8060e-12, 1e-3, 1.55e-6], [8070e-12, 2e-3, 1.55e-6], [8080e-12, 1e-3, 1.55e-6], [8090e-12, 2e-3, 1.55e-6], [8100e-12, 1e-3, 1.55e-6], [8110e-12, 2e-3, 1.55e-6], [8120e-12, 1e-3, 1.55e-6], [8130e-12, 2e-3, 1.55e-6], [8140e-12, 1e-3, 1.55e-6], [8150e-12, 2e-3, 1.55e-6], [8160e-12, 1e-3, 1.55e-6], [8170e-12, 2e-3, 1.55e-6], [8180e-12, 1e-3, 1.55e-6], [8190e-12, 2e-3, 1.55e-6], [8200e-12, 1e-3, 1.55e-6], [8210e-12, 2e-3, 1.55e-6], [8220e-12, 1e-3, 1.55e-6], [8230e-12, 2e-3, 1.55e-6], [8240e-12, 1e-3, 1.55e-6], [8250e-12, 2e-3, 1.55e-6], [8260e-12, 1e-3, 1.55e-6], [8270e-12, 2e-3, 1.55e-6], [8280e-12, 1e-3, 1.55e-6], [8290e-12, 2e-3, 1.55e-6], [8300e-12, 1e-3, 1.55e-6], [8310e-12, 2e-3, 1.55e-6], [8320e-12, 1e-3, 1.55e-6], [8330e-12, 2e-3, 1.55e-6], [8340e-12, 1e-3, 1.55e-6], [8350e-12, 2e-3, 1.55e-6], [8360e-12, 1e-3, 1.55e-6], [8370e-12, 2e-3, 1.55e-6], [8380e-12, 1e-3, 1.55e-6], [8390e-12, 2e-3, 1.55e-6], [8400e-12, 1e-3, 1.55e-6], [8410e-12, 2e-3, 1.55e-6], [8420e-12, 1e-3, 1.55e-6], [8430e-12, 2e-3, 1.55e-6], [8440e-12, 1e-3, 1.55e-6], [8450e-12, 2e-3, 1.55e-6], [8460e-12, 1e-3, 1.55e-6], [8470e-12, 2e-3, 1.55e-6], [8480e-12, 1e-3, 1.55e-6], [8490e-12, 2e-3, 1.55e-6], [8500e-12, 1e-3, 1.55e-6], [8510e-12, 2e-3, 1.55e-6], [8520e-12, 1e-3, 1.55e-6], [8530e-12, 2e-3, 1.55e-6], [8540e-12, 1e-3, 1.55e-6], [8550e-12, 2e-3, 1.55e-6], [8560e-12, 1e-3, 1.55e-6], [8570e-12, 2e-3, 1.55e-6], [8580e-12, 1e-3, 1.55e-6], [8590e-12, 2e-3, 1.55e-6], [8600e-12, 1e-3, 1.55e-6], [8610e-12, 2e-3, 1.55e-6], [8620e-12, 1e-3, 1.55e-6], [8630e-12, 2e-3, 1.55e-6], [8640e-12, 1e-3, 1.55e-6], [8650e-12, 2e-3, 1.55e-6], [8660e-12, 1e-3, 1.55e-6], [8670e-12, 2e-3, 1.55e-6], [8680e-12, 1e-3, 1.55e-6], [8690e-12, 2e-3, 1.55e-6], [8700e-12, 1e-3, 1.55e-6], [8710e-12, 2e-3, 1.55e-6], [8720e-12, 1e-3, 1.55e-6], [8730e-12, 2e-3, 1.55e-6], [8740e-12, 1e-3, 1.55e-6], [8750e-12, 2e-3, 1.55e-6], [8760e-12, 1e-3, 1.55e-6], [8770e-12, 2e-3, 1.55e-6], [8780e-12, 1e-3, 1.55e-6], [8790e-12, 2e-3, 1.55e-6], [8800e-12, 1e-3, 1.55e-6], [8810e-12, 2e-3, 1.55e-6], [8820e-12, 1e-3, 1.55e-6], [8830e-12, 2e-3, 1.55e-6], [8840e-12, 1e-3, 1.55e-6], [8850e-12, 2e-3, 1.55e-6], [8860e-12, 1e-3, 1.55e-6], [8870e-12, 2e-3, 1.55e-6], [8880e-12, 1e-3, 1.55e-6], [8890e-12, 2e-3, 1.55e-6], [8900e-12, 1e-3, 1.55e-6], [8910e-12, 2e-3, 1.55e-6], [8920e-12, 1e-3, 1.55e-6], [8930e-12, 2e-3, 1.55e-6], [8940e-12, 1e-3, 1.55e-6], [8950e-12, 2e-3, 1.55e-6], [8960e-12, 1e-3, 1.55e-6], [8970e-12, 2e-3, 1.55e-6], [8980e-12, 1e-3, 1.55e-6], [8990e-12, 2e-3, 1.55e-6], [9000e-12, 1e-3, 1.55e-6], [9010e-12, 2e-3, 1.55e-6], [9020e-12, 1e-3, 1.55e-6], [9030e-12, 2e-3, 1.55e-6], [9040e-12, 1e-3, 1.55e-6], [9050e-12, 2e-3, 1.55e-6], [9060e-12, 1e-3, 1.55e-6], [9070e-12, 2e-3, 1.55e-6], [9080e-12, 1e-3, 1.55e-6], [9090e-12, 2e-3, 1.55e-6], [9100e-12, 1e-3, 1.55e-6], [9110e-12, 2e-3, 1.55e-6], [9120e-12, 1e-3, 1.55e-6], [9130e-12, 2e-3, 1.55e-6], [9140e-12, 1e-3, 1.55e-6], [9150e-12, 2e-3, 1.55e-6], [9160e-12, 1e-3, 1.55e-6], [9170e-12, 2e-3, 1.55e-6], [9180e-12, 1e-3, 1.55e-6], [9190e-12, 2e-3, 1.55e-6], [9200e-12, 1e-3, 1.55e-6], [9210e-12, 2e-3, 1.55e-6], [9220e-12, 1e-3, 1.55e-6], [9230e-12, 2e-3, 1.55e-6], [9240e-12, 1e-3, 1.55e-6], [9250e-12, 2e-3, 1.55e-6], [9260e-12, 1e-3, 1.55e-6], [9270e-12, 2e-3, 1.55e-6], [9280e-12, 1e-3, 1.55e-6], [9290e-12, 2e-3, 1.55e-6], [9300e-12, 1e-3, 1.55e-6], [9310e-12, 2e-3, 1.55e-6], [9320e-12, 1e-3, 1.55e-6], [9330e-12, 2e-3, 1.55e-6], [9340e-12, 1e-3, 1.55e-6], [9350e-12, 2e-3, 1.55e-6], [9360e-12, 1e-3, 1.55e-6], [9370e-12, 2e-3, 1.55e-6], [9380e-12, 1e-3, 1.55e-6], [9390e-12, 2e-3, 1.55e-6], [9400e-12, 1e-3, 1.55e-6], [9410e-12, 2e-3, 1.55e-6], [9420e-12, 1e-3, 1.55e-6], [9430e-12, 2e-3, 1.55e-6], [9440e-12, 1e-3, 1.55e-6], [9450e-12, 2e-3, 1.55e-6], [9460e-12, 1e-3, 1.55e-6], [9470e-12, 2e-3, 1.55e-6], [9480e-12, 1e-3, 1.55e-6], [9490e-12, 2e-3, 1.55e-6], [9500e-12, 1e-3, 1.55e-6], [9510e-12, 2e-3, 1.55e-6], [9520e-12, 1e-3, 1.55e-6], [9530e-12, 2e-3, 1.55e-6], [9540e-12, 1e-3, 1.55e-6], [9550e-12, 2e-3, 1.55e-6], [9560e-12, 1e-3, 1.55e-6], [9570e-12, 2e-3, 1.55e-6], [9580e-12, 1e-3, 1.55e-6], [9590e-12, 2e-3, 1.55e-6], [9600e-12, 1e-3, 1.55e-6], [9610e-12, 2e-3, 1.55e-6], [9620e-12, 1e-3, 1.55e-6], [9630e-12, 2e-3, 1.55e-6], [9640e-12, 1e-3, 1.55e-6], [9650e-12, 2e-3, 1.55e-6], [9660e-12, 1e-3, 1.55e-6], [9670e-12, 2e-3, 1.55e-6], [9680e-12, 1e-3, 1.55e-6], [9690e-12, 2e-3, 1.55e-6], [9700e-12, 1e-3, 1.55e-6], [9710e-12, 2e-3, 1.55e-6], [9720e-12, 1e-3, 1.55e-6], [9730e-12, 2e-3, 1.55e-6], [9740e-12, 1e-3, 1.55e-6], [9750e-12, 2e-3, 1.55e-6], [9760e-12, 1e-3, 1.55e-6], [9770e-12, 2e-3, 1.55e-6], [9780e-12, 1e-3, 1.55e-6], [9790e-12, 2e-3, 1.55e-6], [9800e-12, 1e-3, 1.55e-6], [9810e-12, 2e-3, 1.55e-6], [9820e-12, 1e-3, 1.55e-6], [9830e-12, 2e-3, 1.55e-6], [9840e-12, 1e-3, 1.55e-6], [9850e-12, 2e-3, 1.55e-6], [9860e-12, 1e-3, 1.55e-6], [9870e-12, 2e-3, 1.55e-6], [9880e-12, 1e-3, 1.55e-6], [9890e-12, 2e-3, 1.55e-6], [9900e-12, 1e-3, 1.55e-6], [9910e-12, 2e-3, 1.55e-6], [9920e-12, 1e-3, 1.55e-6], [9930e-12, 2e-3, 1.55e-6], [9940e-12, 1e-3, 1.55e-6], [9950e-12, 2e-3, 1.55e-6], [9960e-12, 1e-3, 1.55e-6], [9970e-12, 2e-3, 1.55e-6], [9980e-12, 1e-3, 1.55e-6], [9990e-12, 2e-3, 1.55e-6], [10000e-12, 1e-3, 1.55e-6], [10010e-12, 2e-3, 1.55e-6], [10020e-12, 1e-3, 1.55e-6], [10030e-12, 2e-3, 1.55e-6], [10040e-12, 1e-3, 1.55e-6], [10050e-12, 2e-3, 1.55e-6], [10060e-12, 1e-3, 1.55e-6], [10070e-12, 2e-3, 1.55e-6], [10080e-12, 1e-3, 1.55e-6], [10090e-12, 2e-3, 1.55e-6], [10100e-12, 1e-3, 1.55e-6], [10110e-12, 2e-3, 1.55e-6], [10120e-12, 1e-3, 1.55e-6], [10130e-12, 2e-3, 1.55e-6], [10140e-12, 1e-3, 1.55e-6], [10150e-12, 2e-3, 1.55e-6], [10160e-12, 1e-3, 1.55e-6], [10170e-12, 2e-3, 1.55e-6], [10180e-12, 1e-3, 1.55e-6], [10190e-12, 2e-3, 1.55e-6], [10200e-12, 1e-3, 1.55e-6], [10210e-12, 2e-3, 1.55e-6], [10220e-12, 1e-3, 1.55e-6], [10230e-12, 2e-3, 1.55e-6], [10240e-12, 1e-3, 1.55e-6], [10250e-12, 2e-3, 1.55e-6], [10260e-12, 1e-3, 1.55e-6], [10270e-12, 2e-3, 1.55e-6], [10280e-12, 1e-3, 1.55e-6], [10290e-12, 2e-3, 1.55e-6], [10300e-12, 1e-3, 1.55e-6], [10310e-12, 2e-3, 1.55e-6], [10320e-12, 1e-3, 1.55e-6], [10330e-12, 2e-3, 1.55e-6], [10340e-12, 1e-3, 1.55e-6], [10350e-12, 2e-3, 1.55e-6], [10360e-12, 1e-3, 1.55e-6], [10370e-12, 2e-3, 1.55e-6], [10380e-12, 1e-3, 1.55e-6], [10390e-12, 2e-3, 1.55e-6], [10400e-12, 1e-3, 1.55e-6], [10410e-12, 2e-3, 1.55e-6], [10420e-12, 1e-3, 1.55e-6], [10430e-12, 2e-3, 1.55e-6], [10440e-12, 1e-3, 1.55e-6], [10450e-12, 2e-3, 1.55e-6], [10460e-12, 1e-3, 1.55e-6], [10470e-12, 2e-3, 1.55e-6], [10480e-12, 1e-3, 1.55e-6], [10490e-12, 2e-3, 1.55e-6], [10500e-12, 1e-3, 1.55e-6], [10510e-12, 2e-3, 1.55e-6], [10520e-12, 1e-3, 1.55e-6], [10530e-12, 2e-3, 1.55e-6], [10540e-12, 1e-3, 1.55e-6], [10550e-12, 2e-3, 1.55e-6], [10560e-12, 1e-3, 1.55e-6], [10570e-12, 2e-3, 1.55e-6], [10580e-12, 1e-3, 1.55e-6], [10590e-12, 2e-3, 1.55e-6], [10600e-12, 1e-3, 1.55e-6], [10610e-12, 2e-3, 1.55e-6], [10620e-12, 1e-3, 1.55e-6], [10630e-12, 2e-3, 1.55e-6], [10640e-12, 1e-3, 1.55e-6], [10650e-12, 2e-3, 1.55e-6], [10660e-12, 1e-3, 1.55e-6], [10670e-12, 2e-3, 1.55e-6], [10680e-12, 1e-3, 1.55e-6], [10690e-12, 2e-3, 1.55e-6], [10700e-12, 1e-3, 1.55e-6], [10710e-12, 2e-3, 1.55e-6], [10720e-12, 1e-3, 1.55e-6], [10730e-12, 2e-3, 1.55e-6], [10740e-12, 1e-3, 1.55e-6], [10750e-12, 2e-3, 1.55e-6], [10760e-12, 1e-3, 1.55e-6], [10770e-12, 2e-3, 1.55e-6], [10780e-12, 1e-3, 1.55e-6], [10790e-12, 2e-3, 1.55e-6], [10800e-12, 1e-3, 1.55e-6], [10810e-12, 2e-3, 1.55e-6], [10820e-12, 1e-3, 1.55e-6], [10830e-12, 2e-3, 1.55e-6], [10840e-12, 1e-3, 1.55e-6], [10850e-12, 2e-3, 1.55e-6], [10860e-12, 1e-3, 1.55e-6], [10870e-12, 2e-3, 1.55e-6], [10880e-12, 1e-3, 1.55e-6], [10890e-12, 2e-3, 1.55e-6], [10900e-12, 1e-3, 1.55e-6], [10910e-12, 2e-3, 1.55e-6], [10920e-12, 1e-3, 1.55e-6], [10930e-12, 2e-3, 1.55e-6], [10940e-12, 1e-3, 1.55e-6], [10950e-12, 2e-3, 1.55e-6], [10960e-12, 1e-3, 1.55e-6], [10970e-12, 2e-3, 1.55e-6], [10980e-12, 1e-3, 1.55e-6], [10990e-12, 2e-3, 1.55e-6], [11000e-12, 1e-3, 1.55e-6], [11010e-12, 2e-3, 1.55e-6], [11020e-12, 1e-3, 1.55e-6], [11030e-12, 2e-3, 1.55e-6], [11040e-12, 1e-3, 1.55e-6], [11050e-12, 2e-3, 1.55e-6], [11060e-12, 1e-3, 1.55e-6], [11070e-12, 2e-3, 1.55e-6], [11080e-12, 1e-3, 1.55e-6], [11090e-12, 2e-3, 1.55e-6], [11100e-12, 1e-3, 1.55e-6], [11110e-12, 2e-3, 1.55e-6], [11120e-12, 1e-3, 1.55e-6], [11130e-12, 2e-3, 1.55e-6], [11140e-12, 1e-3, 1.55e-6], [11150e-12, 2e-3, 1.55e-6], [11160e-12, 1e-3, 1.55e-6], [11170e-12, 2e-3, 1.55e-6], [11180e-12, 1e-3, 1.55e-6], [11190e-12, 2e-3, 1.55e-6], [11200e-12, 1e-3, 1.55e-6], [11210e-12, 2e-3, 1.55e-6], [11220e-12, 1e-3, 1.55e-6], [11230e-12, 2e-3, 1.55e-6], [11240e-12, 1e-3, 1.55e-6], [11250e-12, 2e-3, 1.55e-6], [11260e-12, 1e-3, 1.55e-6], [11270e-12, 2e-3, 1.55e-6], [11280e-12, 1e-3, 1.55e-6], [11290e-12, 2e-3, 1.55e-6], [11300e-12, 1e-3, 1.55e-6], [11310e-12, 2e-3, 1.55e-6], [11320e-12, 1e-3, 1.55e-6], [11330e-12, 2e-3, 1.55e-6], [11340e-12, 1e-3, 1.55e-6], [11350e-12, 2e-3, 1.55e-6], [11360e-12, 1e-3, 1.55e-6], [11370e-12, 2e-3, 1.55e-6], [11380e-12, 1e-3, 1.55e-6], [11390e-12, 2e-3, 1.55e-6], [11400e-12, 1e-3, 1.55e-6], [11410e-12, 2e-3, 1.55e-6], [11420e-12, 1e-3, 1.55e-6], [11430e-12, 2e-3, 1.55e-6], [11440e-12, 1e-3, 1.55e-6], [11450e-12, 2e-3, 1.55e-6], [11460e-12, 1e-3, 1.55e-6], [11470e-12, 2e-3, 1.55e-6], [11480e-12, 1e-3, 1.55e-6], [11490e-12, 2e-3, 1.55e-6], [11500e-12, 1e-3, 1.55e-6], [11510e-12, 2e-3, 1.55e-6], [11520e-12, 1e-3, 1.55e-6], [11530e-12, 2e-3, 1.55e-6], [11540e-12, 1e-3, 1.55e-6], [11550e-12, 2e-3, 1.55e-6], [11560e-12, 1e-3, 1.55e-6], [11570e-12, 2e-3, 1.55e-6], [11580e-12, 1e-3, 1.55e-6], [11590e-12, 2e-3, 1.55e-6], [11600e-12, 1e-3, 1.55e-6], [11610e-12, 2e-3, 1.55e-6], [11620e-12, 1e-3, 1.55e-6], [11630e-12, 2e-3, 1.55e-6], [11640e-12, 1e-3, 1.55e-6], [11650e-12, 2e-3, 1.55e-6], [11660e-12, 1e-3, 1.55e-6], [11670e-12, 2e-3, 1.55e-6], [11680e-12, 1e-3, 1.55e-6], [11690e-12, 2e-3, 1.55e-6], [11700e-12, 1e-3, 1.55e-6], [11710e-12, 2e-3, 1.55e-6], [11720e-12, 1e-3, 1.55e-6], [11730e-12, 2e-3, 1.55e-6], [11740e-12, 1e-3, 1.55e-6], [11750e-12, 2e-3, 1.55e-6], [11760e-12, 1e-3, 1.55e-6], [11770e-12, 2e-3, 1.55e-6], [11780e-12, 1e-3, 1.55e-6], [11790e-12, 2e-3, 1.55e-6], [11800e-12, 1e-3, 1.55e-6], [11810e-12, 2e-3, 1.55e-6], [11820e-12, 1e-3, 1.55e-6], [11830e-12, 2e-3, 1.55e-6], [11840e-12, 1e-3, 1.55e-6], [11850e-12, 2e-3, 1.55e-6], [11860e-12, 1e-3, 1.55e-6], [11870e-12, 2e-3, 1.55e-6], [11880e-12, 1e-3, 1.55e-6], [11890e-12, 2e-3, 1.55e-6], [11900e-12, 1e-3, 1.55e-6], [11910e-12, 2e-3, 1.55e-6], [11920e-12, 1e-3, 1.55e-6], [11930e-12, 2e-3, 1.55e-6], [11940e-12, 1e-3, 1.55e-6], [11950e-12, 2e-3, 1.55e-6], [11960e-12, 1e-3, 1.55e-6], [11970e-12, 2e-3, 1.55e-6], [11980e-12, 1e-3, 1.55e-6], [11990e-12, 2e-3, 1.55e-6], [12000e-12, 1e-3, 1.55e-6], [12010e-12, 2e-3, 1.55e-6], [12020e-12, 1e-3, 1.55e-6], [12030e-12, 2e-3, 1.55e-6], [12040e-12, 1e-3, 1.55e-6], [12050e-12, 2e-3, 1.55e-6], [12060e-12, 1e-3, 1.55e-6], [12070e-12, 2e-3, 1.55e-6], [12080e-12, 1e-3, 1.55e-6], [12090e-12, 2e-3, 1.55e-6], [12100e-12, 1e-3, 1.55e-6], [12110e-12, 2e-3, 1.55e-6], [12120e-12, 1e-3, 1.55e-6], [12130e-12, 2e-3, 1.55e-6], [12140e-12, 1e-3, 1.55e-6], [12150e-12, 2e-3, 1.55e-6], [12160e-12, 1e-3, 1.55e-6], [12170e-12, 2e-3, 1.55e-6], [12180e-12, 1e-3, 1.55e-6], [12190e-12, 2e-3, 1.55e-6], [12200e-12, 1e-3, 1.55e-6], [12210e-12, 2e-3, 1.55e-6], [12220e-12, 1e-3, 1.55e-6], [12230e-12, 2e-3, 1.55e-6], [12240e-12, 1e-3, 1.55e-6], [12250e-12, 2e-3, 1.55e-6], [12260e-12, 1e-3, 1.55e-6], [12270e-12, 2e-3, 1.55e-6], [12280e-12, 1e-3, 1.55e-6], [12290e-12, 2e-3, 1.55e-6], [12300e-12, 1e-3, 1.55e-6], [12310e-12, 2e-3, 1.55e-6], [12320e-12, 1e-3, 1.55e-6], [12330e-12, 2e-3, 1.55e-6], [12340e-12, 1e-3, 1.55e-6], [12350e-12, 2e-3, 1.55e-6], [12360e-12, 1e-3, 1.55e-6], [12370e-12, 2e-3, 1.55e-6], [12380e-12, 1e-3, 1.55e-6], [12390e-12, 2e-3, 1.55e-6], [12400e-12, 1e-3, 1.55e-6], [12410e-12, 2e-3, 1.55e-6], [12420e-12, 1e-3, 1.55e-6], [12430e-12, 2e-3, 1.55e-6], [12440e-12, 1e-3, 1.55e-6], [12450e-12, 2e-3, 1.55e-6], [12460e-12, 1e-3, 1.55e-6], [12470e-12, 2e-3, 1.55e-6], [12480e-12, 1e-3, 1.55e-6], [12490e-12, 2e-3, 1.55e-6], [12500e-12, 1e-3, 1.55e-6], [12510e-12, 2e-3, 1.55e-6], [12520e-12, 1e-3, 1.55e-6], [12530e-12, 2e-3, 1.55e-6], [12540e-12, 1e-3, 1.55e-6], [12550e-12, 2e-3, 1.55e-6], [12560e-12, 1e-3, 1.55e-6], [12570e-12, 2e-3, 1.55e-6], [12580e-12, 1e-3, 1.55e-6], [12590e-12, 2e-3, 1.55e-6], [12600e-12, 1e-3, 1.55e-6], [12610e-12, 2e-3, 1.55e-6], [12620e-12, 1e-3, 1.55e-6], [12630e-12, 2e-3, 1.55e-6], [12640e-12, 1e-3, 1.55e-6], [12650e-12, 2e-3, 1.55e-6], [12660e-12, 1e-3, 1.55e-6], [12670e-12, 2e-3, 1.55e-6], [12680e-12, 1e-3, 1.55e-6], [12690e-12, 2e-3, 1.55e-6], [12700e-12, 1e-3, 1.55e-6], [12710e-12, 2e-3, 1.55e-6], [12720e-12, 1e-3, 1.55e-6], [12730e-12, 2e-3, 1.55e-6], [12740e-12, 1e-3, 1.55e-6], [12750e-12, 2e-3, 1.55e-6], [12760e-12, 1e-3, 1.55e-6], [12770e-12, 2e-3, 1.55e-6], [12780e-12, 1e-3, 1.55e-6], [12790e-12, 2e-3, 1.55e-6], [12800e-12, 1e-3, 1.55e-6], [12810e-12, 2e-3, 1.55e-6], [12820e-12, 1e-3, 1.55e-6], [12830e-12, 2e-3, 1.55e-6], [12840e-12, 1e-3, 1.55e-6], [12850e-12, 2e-3, 1.55e-6], [12860e-12, 1e-3, 1.55e-6], [12870e-12, 2e-3, 1.55e-6], [12880e-12, 1e-3, 1.55e-6], [12890e-12, 2e-3, 1.55e-6], [12900e-12, 1e-3, 1.55e-6], [12910e-12, 2e-3, 1.55e-6], [12920e-12, 1e-3, 1.55e-6], [12930e-12, 2e-3, 1.55e-6], [12940e-12, 1e-3, 1.55e-6], [12950e-12, 2e-3, 1.55e-6], [12960e-12, 1e-3, 1.55e-6], [12970e-12, 2e-3, 1.55e-6], [12980e-12, 1e-3, 1.55e-6], [12990e-12, 2e-3, 1.55e-6], [13000e-12, 1e-3, 1.55e-6], [13010e-12, 2e-3, 1.55e-6], [13020e-12, 1e-3, 1.55e-6], [13030e-12, 2e-3, 1.55e-6], [13040e-12, 1e-3, 1.55e-6], [13050e-12, 2e-3, 1.55e-6], [13060e-12, 1e-3, 1.55e-6], [13070e-12, 2e-3, 1.55e-6], [13080e-12, 1e-3, 1.55e-6], [13090e-12, 2e-3, 1.55e-6], [13100e-12, 1e-3, 1.55e-6], [13110e-12, 2e-3, 1.55e-6], [13120e-12, 1e-3, 1.55e-6], [13130e-12, 2e-3, 1.55e-6], [13140e-12, 1e-3, 1.55e-6], [13150e-12, 2e-3, 1.55e-6], [13160e-12, 1e-3, 1.55e-6], [13170e-12, 2e-3, 1.55e-6], [13180e-12, 1e-3, 1.55e-6], [13190e-12, 2e-3, 1.55e-6], [13200e-12, 1e-3, 1.55e-6], [13210e-12, 2e-3, 1.55e-6], [13220e-12, 1e-3, 1.55e-6], [13230e-12, 2e-3, 1.55e-6], [13240e-12, 1e-3, 1.55e-6], [13250e-12, 2e-3, 1.55e-6], [13260e-12, 1e-3, 1.55e-6], [13270e-12, 2e-3, 1.55e-6], [13280e-12, 1e-3, 1.55e-6], [13290e-12, 2e-3, 1.55e-6], [13300e-12, 1e-3, 1.55e-6], [13310e-12, 2e-3, 1.55e-6], [13320e-12, 1e-3, 1.55e-6], [13330e-12, 2e-3, 1.55e-6], [13340e-12, 1e-3, 1.55e-6], [13350e-12, 2e-3, 1.55e-6], [13360e-12, 1e-3, 1.55e-6], [13370e-12, 2e-3, 1.55e-6], [13380e-12, 1e-3, 1.55e-6], [13390e-12, 2e-3, 1.55e-6], [13400e-12, 1e-3, 1.55e-6], [13410e-12, 2e-3, 1.55e-6], [13420e-12, 1e-3, 1.55e-6], [13430e-12, 2e-3, 1.55e-6], [13440e-12, 1e-3, 1.55e-6], [13450e-12, 2e-3, 1.55e-6], [13460e-12, 1e-3, 1.55e-6], [13470e-12, 2e-3, 1.55e-6], [13480e-12, 1e-3, 1.55e-6], [13490e-12, 2e-3, 1.55e-6], [13500e-12, 1e-3, 1.55e-6], [13510e-12, 2e-3, 1.55e-6], [13520e-12, 1e-3, 1.55e-6], [13530e-12, 2e-3, 1.55e-6], [13540e-12, 1e-3, 1.55e-6], [13550e-12, 2e-3, 1.55e-6], [13560e-12, 1e-3, 1.55e-6], [13570e-12, 2e-3, 1.55e-6], [13580e-12, 1e-3, 1.55e-6], [13590e-12, 2e-3, 1.55e-6], [13600e-12, 1e-3, 1.55e-6], [13610e-12, 2e-3, 1.55e-6], [13620e-12, 1e-3, 1.55e-6], [13630e-12, 2e-3, 1.55e-6], [13640e-12, 1e-3, 1.55e-6], [13650e-12, 2e-3, 1.55e-6], [13660e-12, 1e-3, 1.55e-6], [13670e-12, 2e-3, 1.55e-6], [13680e-12, 1e-3, 1.55e-6], [13690e-12, 2e-3, 1.55e-6], [13700e-12, 1e-3, 1.55e-6], [13710e-12, 2e-3, 1.55e-6], [13720e-12, 1e-3, 1.55e-6], [13730e-12, 2e-3, 1.55e-6], [13740e-12, 1e-3, 1.55e-6], [13750e-12, 2e-3, 1.55e-6], [13760e-12, 1e-3, 1.55e-6], [13770e-12, 2e-3, 1.55e-6], [13780e-12, 1e-3, 1.55e-6], [13790e-12, 2e-3, 1.55e-6], [13800e-12, 1e-3, 1.55e-6], [13810e-12, 2e-3, 1.55e-6], [13820e-12, 1e-3, 1.55e-6], [13830e-12, 2e-3, 1.55e-6], [13840e-12, 1e-3, 1.55e-6], [13850e-12, 2e-3, 1.55e-6], [13860e-12, 1e-3, 1.55e-6], [13870e-12, 2e-3, 1.55e-6], [13880e-12, 1e-3, 1.55e-6], [13890e-12, 2e-3, 1.55e-6], [13900e-12, 1e-3, 1.55e-6], [13910e-12, 2e-3, 1.55e-6], [13920e-12, 1e-3, 1.55e-6], [13930e-12, 2e-3, 1.55e-6], [13940e-12, 1e-3, 1.55e-6], [13950e-12, 2e-3, 1.55e-6], [13960e-12, 1e-3, 1.55e-6], [13970e-12, 2e-3, 1.55e-6], [13980e-12, 1e-3, 1.55e-6], [13990e-12, 2e-3, 1.55e-6], [14000e-12, 1e-3, 1.55e-6], [14010e-12, 2e-3, 1.55e-6], [14020e-12, 1e-3, 1.55e-6], [14030e-12, 2e-3, 1.55e-6], [14040e-12, 1e-3, 1.55e-6], [14050e-12, 2e-3, 1.55e-6], [14060e-12, 1e-3, 1.55e-6], [14070e-12, 2e-3, 1.55e-6], [14080e-12, 1e-3, 1.55e-6], [14090e-12, 2e-3, 1.55e-6], [14100e-12, 1e-3, 1.55e-6], [14110e-12, 2e-3, 1.55e-6], [14120e-12, 1e-3, 1.55e-6], [14130e-12, 2e-3, 1.55e-6], [14140e-12, 1e-3, 1.55e-6], [14150e-12, 2e-3, 1.55e-6], [14160e-12, 1e-3, 1.55e-6], [14170e-12, 2e-3, 1.55e-6], [14180e-12, 1e-3, 1.55e-6], [14190e-12, 2e-3, 1.55e-6], [14200e-12, 1e-3, 1.55e-6], [14210e-12, 2e-3, 1.55e-6], [14220e-12, 1e-3, 1.55e-6], [14230e-12, 2e-3, 1.55e-6], [14240e-12, 1e-3, 1.55e-6], [14250e-12, 2e-3, 1.55e-6], [14260e-12, 1e-3, 1.55e-6], [14270e-12, 2e-3, 1.55e-6], [14280e-12, 1e-3, 1.55e-6], [14290e-12, 2e-3, 1.55e-6], [14300e-12, 1e-3, 1.55e-6], [14310e-12, 2e-3, 1.55e-6], [14320e-12, 1e-3, 1.55e-6], [14330e-12, 2e-3, 1.55e-6], [14340e-12, 1e-3, 1.55e-6], [14350e-12, 2e-3, 1.55e-6], [14360e-12, 1e-3, 1.55e-6], [14370e-12, 2e-3, 1.55e-6], [14380e-12, 1e-3, 1.55e-6], [14390e-12, 2e-3, 1.55e-6], [14400e-12, 1e-3, 1.55e-6], [14410e-12, 2e-3, 1.55e-6], [14420e-12, 1e-3, 1.55e-6], [14430e-12, 2e-3, 1.55e-6], [14440e-12, 1e-3, 1.55e-6], [14450e-12, 2e-3, 1.55e-6], [14460e-12, 1e-3, 1.55e-6], [14470e-12, 2e-3, 1.55e-6], [14480e-12, 1e-3, 1.55e-6], [14490e-12, 2e-3, 1.55e-6], [14500e-12, 1e-3, 1.55e-6], [14510e-12, 2e-3, 1.55e-6], [14520e-12, 1e-3, 1.55e-6], [14530e-12, 2e-3, 1.55e-6], [14540e-12, 1e-3, 1.55e-6], [14550e-12, 2e-3, 1.55e-6], [14560e-12, 1e-3, 1.55e-6], [14570e-12, 2e-3, 1.55e-6], [14580e-12, 1e-3, 1.55e-6], [14590e-12, 2e-3, 1.55e-6], [14600e-12, 1e-3, 1.55e-6], [14610e-12, 2e-3, 1.55e-6], [14620e-12, 1e-3, 1.55e-6], [14630e-12, 2e-3, 1.55e-6], [14640e-12, 1e-3, 1.55e-6], [14650e-12, 2e-3, 1.55e-6], [14660e-12, 1e-3, 1.55e-6], [14670e-12, 2e-3, 1.55e-6], [14680e-12, 1e-3, 1.55e-6], [14690e-12, 2e-3, 1.55e-6], [14700e-12, 1e-3, 1.55e-6], [14710e-12, 2e-3, 1.55e-6], [14720e-12, 1e-3, 1.55e-6], [14730e-12, 2e-3, 1.55e-6], [14740e-12, 1e-3, 1.55e-6], [14750e-12, 2e-3, 1.55e-6], [14760e-12, 1e-3, 1.55e-6], [14770e-12, 2e-3, 1.55e-6], [14780e-12, 1e-3, 1.55e-6], [14790e-12, 2e-3, 1.55e-6], [14800e-12, 1e-3, 1.55e-6], [14810e-12, 2e-3, 1.55e-6], [14820e-12, 1e-3, 1.55e-6], [14830e-12, 2e-3, 1.55e-6], [14840e-12, 1e-3, 1.55e-6], [14850e-12, 2e-3, 1.55e-6], [14860e-12, 1e-3, 1.55e-6], [14870e-12, 2e-3, 1.55e-6], [14880e-12, 1e-3, 1.55e-6], [14890e-12, 2e-3, 1.55e-6], [14900e-12, 1e-3, 1.55e-6], [14910e-12, 2e-3, 1.55e-6], [14920e-12, 1e-3, 1.55e-6], [14930e-12, 2e-3, 1.55e-6], [14940e-12, 1e-3, 1.55e-6], [14950e-12, 2e-3, 1.55e-6], [14960e-12, 1e-3, 1.55e-6], [14970e-12, 2e-3, 1.55e-6], [14980e-12, 1e-3, 1.55e-6], [14990e-12, 2e-3, 1.55e-6], [15000e-12, 1e-3, 1.55e-6], [15010e-12, 2e-3, 1.55e-6], [15020e-12, 1e-3, 1.55e-6], [15030e-12, 2e-3, 1.55e-6], [15040e-12, 1e-3, 1.55e-6], [15050e-12, 2e-3, 1.55e-6], [15060e-12, 1e-3, 1.55e-6], [15070e-12, 2e-3, 1.55e-6], [15080e-12, 1e-3, 1.55e-6], [15090e-12, 2e-3, 1.55e-6], [15100e-12, 1e-3, 1.55e-6], [15110e-12, 2e-3, 1.55e-6], [15120e-12, 1e-3, 1.55e-6], [15130e-12, 2e-3, 1.55e-6], [15140e-12, 1e-3, 1.55e-6], [15150e-12, 2e-3, 1.55e-6], [15160e-12, 1e-3, 1.55e-6], [15170e-12, 2e-3, 1.55e-6], [15180e-12, 1e-3, 1.55e-6], [15190e-12, 2e-3, 1.55e-6], [15200e-12, 1e-3, 1.55e-6], [15210e-12, 2e-3, 1.55e-6], [15220e-12, 1e-3, 1.55e-6], [15230e-12, 2e-3, 1.55e-6], [15240e-12, 1e-3, 1.55e-6], [15250e-12, 2e-3, 1.55e-6], [15260e-12, 1e-3, 1.55e-6], [15270e-12, 2e-3, 1.55e-6], [15280e-12, 1e-3, 1.55e-6], [15290e-12, 2e-3, 1.55e-6], [15300e-12, 1e-3, 1.55e-6], [15310e-12, 2e-3, 1.55e-6], [15320e-12, 1e-3, 1.55e-6], [15330e-12, 2e-3, 1.55e-6], [15340e-12, 1e-3, 1.55e-6], [15350e-12, 2e-3, 1.55e-6], [15360e-12, 1e-3, 1.55e-6], [15370e-12, 2e-3, 1.55e-6], [15380e-12, 1e-3, 1.55e-6], [15390e-12, 2e-3, 1.55e-6], [15400e-12, 1e-3, 1.55e-6], [15410e-12, 2e-3, 1.55e-6], [15420e-12, 1e-3, 1.55e-6], [15430e-12, 2e-3, 1.55e-6], [15440e-12, 1e-3, 1.55e-6], [15450e-12, 2e-3, 1.55e-6], [15460e-12, 1e-3, 1.55e-6], [15470e-12, 2e-3, 1.55e-6], [15480e-12, 1e-3, 1.55e-6], [15490e-12, 2e-3, 1.55e-6], [15500e-12, 1e-3, 1.55e-6], [15510e-12, 2e-3, 1.55e-6], [15520e-12, 1e-3, 1.55e-6], [15530e-12, 2e-3, 1.55e-6], [15540e-12, 1e-3, 1.55e-6], [15550e-12, 2e-3, 1.55e-6], [15560e-12, 1e-3, 1.55e-6], [15570e-12, 2e-3, 1.55e-6], [15580e-12, 1e-3, 1.55e-6], [15590e-12, 2e-3, 1.55e-6], [15600e-12, 1e-3, 1.55e-6], [15610e-12, 2e-3, 1.55e-6], [15620e-12, 1e-3, 1.55e-6], [15630e-12, 2e-3, 1.55e-6], [15640e-12, 1e-3, 1.55e-6], [15650e-12, 2e-3, 1.55e-6], [15660e-12, 1e-3, 1.55e-6], [15670e-12, 2e-3, 1.55e-6], [15680e-12, 1e-3, 1.55e-6], [15690e-12, 2e-3, 1.55e-6], [15700e-12, 1e-3, 1.55e-6], [15710e-12, 2e-3, 1.55e-6], [15720e-12, 1e-3, 1.55e-6], [15730e-12, 2e-3, 1.55e-6], [15740e-12, 1e-3, 1.55e-6], [15750e-12, 2e-3, 1.55e-6], [15760e-12, 1e-3, 1.55e-6], [15770e-12, 2e-3, 1.55e-6], [15780e-12, 1e-3, 1.55e-6], [15790e-12, 2e-3, 1.55e-6], [15800e-12, 1e-3, 1.55e-6], [15810e-12, 2e-3, 1.55e-6], [15820e-12, 1e-3, 1.55e-6], [15830e-12, 2e-3, 1.55e-6], [15840e-12, 1e-3, 1.55e-6], [15850e-12, 2e-3, 1.55e-6], [15860e-12, 1e-3, 1.55e-6], [15870e-12, 2e-3, 1.55e-6], [15880e-12, 1e-3, 1.55e-6], [15890e-12, 2e-3, 1.55e-6], [15900e-12, 1e-3, 1.55e-6], [15910e-12, 2e-3, 1.55e-6], [15920e-12, 1e-3, 1.55e-6], [15930e-12, 2e-3, 1.55e-6], [15940e-12, 1e-3, 1.55e-6], [15950e-12, 2e-3, 1.55e-6], [15960e-12, 1e-3, 1.55e-6], [15970e-12, 2e-3, 1.55e-6], [15980e-12, 1e-3, 1.55e-6], [15990e-12, 2e-3, 1.55e-6], [16000e-12, 1e-3, 1.55e-6], [16010e-12, 2e-3, 1.55e-6], [16020e-12, 1e-3, 1.55e-6], [16030e-12, 2e-3, 1.55e-6], [16040e-12, 1e-3, 1.55e-6], [16050e-12, 2e-3, 1.55e-6], [16060e-12, 1e-3, 1.55e-6], [16070e-12, 2e-3, 1.55e-6], [16080e-12, 1e-3, 1.55e-6], [16090e-12, 2e-3, 1.55e-6], [16100e-12, 1e-3, 1.55e-6], [16110e-12, 2e-3, 1.55e-6], [16120e-12, 1e-3, 1.55e-6], [16130e-12, 2e-3, 1.55e-6], [16140e-12, 1e-3, 1.55e-6], [16150e-12, 2e-3, 1.55e-6], [16160e-12, 1e-3, 1.55e-6], [16170e-12, 2e-3, 1.55e-6], [16180e-12, 1e-3, 1.55e-6], [16190e-12, 2e-3, 1.55e-6], [16200e-12, 1e-3, 1.55e-6], [16210e-12, 2e-3, 1.55e-6], [16220e-12, 1e-3, 1.55e-6], [16230e-12, 2e-3, 1.55e-6], [16240e-12, 1e-3, 1.55e-6], [16250e-12, 2e-3, 1.55e-6], [16260e-12, 1e-3, 1.55e-6], [16270e-12, 2e-3, 1.55e-6], [16280e-12, 1e-3, 1.55e-6], [16290e-12, 2e-3, 1.55e-6], [16300e-12, 1e-3, 1.55e-6], [16310e-12, 2e-3, 1.55e-6], [16320e-12, 1e-3, 1.55e-6], [16330e-12, 2e-3, 1.55e-6], [16340e-12, 1e-3, 1.55e-6], [16350e-12, 2e-3, 1.55e-6], [16360e-12, 1e-3, 1.55e-6], [16370e-12, 2e-3, 1.55e-6], [16380e-12, 1e-3, 1.55e-6], [16390e-12, 2e-3, 1.55e-6], [16400e-12, 1e-3, 1.55e-6], [16410e-12, 2e-3, 1.55e-6], [16420e-12, 1e-3, 1.55e-6], [16430e-12, 2e-3, 1.55e-6], [16440e-12, 1e-3, 1.55e-6], [16450e-12, 2e-3, 1.55e-6], [16460e-12, 1e-3, 1.55e-6], [16470e-12, 2e-3, 1.55e-6], [16480e-12, 1e-3, 1.55e-6], [16490e-12, 2e-3, 1.55e-6], [16500e-12, 1e-3, 1.55e-6], [16510e-12, 2e-3, 1.55e-6], [16520e-12, 1e-3, 1.55e-6], [16530e-12, 2e-3, 1.55e-6], [16540e-12, 1e-3, 1.55e-6], [16550e-12, 2e-3, 1.55e-6], [16560e-12, 1e-3, 1.55e-6], [16570e-12, 2e-3, 1.55e-6], [16580e-12, 1e-3, 1.55e-6], [16590e-12, 2e-3, 1.55e-6], [16600e-12, 1e-3, 1.55e-6], [16610e-12, 2e-3, 1.55e-6], [16620e-12, 1e-3, 1.55e-6], [16630e-12, 2e-3, 1.55e-6], [16640e-12, 1e-3, 1.55e-6], [16650e-12, 2e-3, 1.55e-6], [16660e-12, 1e-3, 1.55e-6], [16670e-12, 2e-3, 1.55e-6], [16680e-12, 1e-3, 1.55e-6], [16690e-12, 2e-3, 1.55e-6], [16700e-12, 1e-3, 1.55e-6], [16710e-12, 2e-3, 1.55e-6], [16720e-12, 1e-3, 1.55e-6], [16730e-12, 2e-3, 1.55e-6], [16740e-12, 1e-3, 1.55e-6], [16750e-12, 2e-3, 1.55e-6], [16760e-12, 1e-3, 1.55e-6], [16770e-12, 2e-3, 1.55e-6], [16780e-12, 1e-3, 1.55e-6], [16790e-12, 2e-3, 1.55e-6], [16800e-12, 1e-3, 1.55e-6], [16810e-12, 2e-3, 1.55e-6], [16820e-12, 1e-3, 1.55e-6], [16830e-12, 2e-3, 1.55e-6], [16840e-12, 1e-3, 1.55e-6], [16850e-12, 2e-3, 1.55e-6], [16860e-12, 1e-3, 1.55e-6], [16870e-12, 2e-3, 1.55e-6], [16880e-12, 1e-3, 1.55e-6], [16890e-12, 2e-3, 1.55e-6], [16900e-12, 1e-3, 1.55e-6], [16910e-12, 2e-3, 1.55e-6], [16920e-12, 1e-3, 1.55e-6], [16930e-12, 2e-3, 1.55e-6], [16940e-12, 1e-3, 1.55e-6], [16950e-12, 2e-3, 1.55e-6], [16960e-12, 1e-3, 1.55e-6], [16970e-12, 2e-3, 1.55e-6], [16980e-12, 1e-3, 1.55e-6], [16990e-12, 2e-3, 1.55e-6], [17000e-12, 1e-3, 1.55e-6], [17010e-12, 2e-3, 1.55e-6], [17020e-12, 1e-3, 1.55e-6], [17030e-12, 2e-3, 1.55e-6], [17040e-12, 1e-3, 1.55e-6], [17050e-12, 2e-3, 1.55e-6], [17060e-12, 1e-3, 1.55e-6], [17070e-12, 2e-3, 1.55e-6], [17080e-12, 1e-3, 1.55e-6], [17090e-12, 2e-3, 1.55e-6], [17100e-12, 1e-3, 1.55e-6], [17110e-12, 2e-3, 1.55e-6], [17120e-12, 1e-3, 1.55e-6], [17130e-12, 2e-3, 1.55e-6], [17140e-12, 1e-3, 1.55e-6], [17150e-12, 2e-3, 1.55e-6], [17160e-12, 1e-3, 1.55e-6], [17170e-12, 2e-3, 1.55e-6], [17180e-12, 1e-3, 1.55e-6], [17190e-12, 2e-3, 1.55e-6], [17200e-12, 1e-3, 1.55e-6], [17210e-12, 2e-3, 1.55e-6], [17220e-12, 1e-3, 1.55e-6], [17230e-12, 2e-3, 1.55e-6], [17240e-12, 1e-3, 1.55e-6], [17250e-12, 2e-3, 1.55e-6], [17260e-12, 1e-3, 1.55e-6], [17270e-12, 2e-3, 1.55e-6], [17280e-12, 1e-3, 1.55e-6], [17290e-12, 2e-3, 1.55e-6], [17300e-12, 1e-3, 1.55e-6], [17310e-12, 2e-3, 1.55e-6], [17320e-12, 1e-3, 1.55e-6], [17330e-12, 2e-3, 1.55e-6], [17340e-12, 1e-3, 1.55e-6], [17350e-12, 2e-3, 1.55e-6], [17360e-12, 1e-3, 1.55e-6], [17370e-12, 2e-3, 1.55e-6], [17380e-12, 1e-3, 1.55e-6], [17390e-12, 2e-3, 1.55e-6], [17400e-12, 1e-3, 1.55e-6], [17410e-12, 2e-3, 1.55e-6], [17420e-12, 1e-3, 1.55e-6], [17430e-12, 2e-3, 1.55e-6], [17440e-12, 1e-3, 1.55e-6], [17450e-12, 2e-3, 1.55e-6], [17460e-12, 1e-3, 1.55e-6], [17470e-12, 2e-3, 1.55e-6], [17480e-12, 1e-3, 1.55e-6], [17490e-12, 2e-3, 1.55e-6], [17500e-12, 1e-3, 1.55e-6], [17510e-12, 2e-3, 1.55e-6], [17520e-12, 1e-3, 1.55e-6], [17530e-12, 2e-3, 1.55e-6], [17540e-12, 1e-3, 1.55e-6], [17550e-12, 2e-3, 1.55e-6], [17560e-12, 1e-3, 1.55e-6], [17570e-12, 2e-3, 1.55e-6], [17580e-12, 1e-3, 1.55e-6], [17590e-12, 2e-3, 1.55e-6], [17600e-12, 1e-3, 1.55e-6], [17610e-12, 2e-3, 1.55e-6], [17620e-12, 1e-3, 1.55e-6], [17630e-12, 2e-3, 1.55e-6], [17640e-12, 1e-3, 1.55e-6], [17650e-12, 2e-3, 1.55e-6], [17660e-12, 1e-3, 1.55e-6], [17670e-12, 2e-3, 1.55e-6], [17680e-12, 1e-3, 1.55e-6], [17690e-12, 2e-3, 1.55e-6], [17700e-12, 1e-3, 1.55e-6], [17710e-12, 2e-3, 1.55e-6], [17720e-12, 1e-3, 1.55e-6], [17730e-12, 2e-3, 1.55e-6], [17740e-12, 1e-3, 1.55e-6], [17750e-12, 2e-3, 1.55e-6], [17760e-12, 1e-3, 1.55e-6], [17770e-12, 2e-3, 1.55e-6], [17780e-12, 1e-3, 1.55e-6], [17790e-12, 2e-3, 1.55e-6], [17800e-12, 1e-3, 1.55e-6], [17810e-12, 2e-3, 1.55e-6], [17820e-12, 1e-3, 1.55e-6], [17830e-12, 2e-3, 1.55e-6], [17840e-12, 1e-3, 1.55e-6], [17850e-12, 2e-3, 1.55e-6], [17860e-12, 1e-3, 1.55e-6], [17870e-12, 2e-3, 1.55e-6], [17880e-12, 1e-3, 1.55e-6], [17890e-12, 2e-3, 1.55e-6], [17900e-12, 1e-3, 1.55e-6], [17910e-12, 2e-3, 1.55e-6], [17920e-12, 1e-3, 1.55e-6], [17930e-12, 2e-3, 1.55e-6], [17940e-12, 1e-3, 1.55e-6], [17950e-12, 2e-3, 1.55e-6], [17960e-12, 1e-3, 1.55e-6], [17970e-12, 2e-3, 1.55e-6], [17980e-12, 1e-3, 1.55e-6], [17990e-12, 2e-3, 1.55e-6], [18000e-12, 1e-3, 1.55e-6], [18010e-12, 2e-3, 1.55e-6], [18020e-12, 1e-3, 1.55e-6], [18030e-12, 2e-3, 1.55e-6], [18040e-12, 1e-3, 1.55e-6], [18050e-12, 2e-3, 1.55e-6], [18060e-12, 1e-3, 1.55e-6], [18070e-12, 2e-3, 1.55e-6], [18080e-12, 1e-3, 1.55e-6], [18090e-12, 2e-3, 1.55e-6], [18100e-12, 1e-3, 1.55e-6], [18110e-12, 2e-3, 1.55e-6], [18120e-12, 1e-3, 1.55e-6], [18130e-12, 2e-3, 1.55e-6], [18140e-12, 1e-3, 1.55e-6], [18150e-12, 2e-3, 1.55e-6], [18160e-12, 1e-3, 1.55e-6], [18170e-12, 2e-3, 1.55e-6], [18180e-12, 1e-3, 1.55e-6], [18190e-12, 2e-3, 1.55e-6], [18200e-12, 1e-3, 1.55e-6], [18210e-12, 2e-3, 1.55e-6], [18220e-12, 1e-3, 1.55e-6], [18230e-12, 2e-3, 1.55e-6], [18240e-12, 1e-3, 1.55e-6], [18250e-12, 2e-3, 1.55e-6], [18260e-12, 1e-3, 1.55e-6], [18270e-12, 2e-3, 1.55e-6], [18280e-12, 1e-3, 1.55e-6], [18290e-12, 2e-3, 1.55e-6], [18300e-12, 1e-3, 1.55e-6], [18310e-12, 2e-3, 1.55e-6], [18320e-12, 1e-3, 1.55e-6], [18330e-12, 2e-3, 1.55e-6], [18340e-12, 1e-3, 1.55e-6], [18350e-12, 2e-3, 1.55e-6], [18360e-12, 1e-3, 1.55e-6], [18370e-12, 2e-3, 1.55e-6], [18380e-12, 1e-3, 1.55e-6], [18390e-12, 2e-3, 1.55e-6], [18400e-12, 1e-3, 1.55e-6], [18410e-12, 2e-3, 1.55e-6], [18420e-12, 1e-3, 1.55e-6], [18430e-12, 2e-3, 1.55e-6], [18440e-12, 1e-3, 1.55e-6], [18450e-12, 2e-3, 1.55e-6], [18460e-12, 1e-3, 1.55e-6], [18470e-12, 2e-3, 1.55e-6], [18480e-12, 1e-3, 1.55e-6], [18490e-12, 2e-3, 1.55e-6], [18500e-12, 1e-3, 1.55e-6], [18510e-12, 2e-3, 1.55e-6], [18520e-12, 1e-3, 1.55e-6], [18530e-12, 2e-3, 1.55e-6], [18540e-12, 1e-3, 1.55e-6], [18550e-12, 2e-3, 1.55e-6], [18560e-12, 1e-3, 1.55e-6], [18570e-12, 2e-3, 1.55e-6], [18580e-12, 1e-3, 1.55e-6], [18590e-12, 2e-3, 1.55e-6], [18600e-12, 1e-3, 1.55e-6], [18610e-12, 2e-3, 1.55e-6], [18620e-12, 1e-3, 1.55e-6], [18630e-12, 2e-3, 1.55e-6], [18640e-12, 1e-3, 1.55e-6], [18650e-12, 2e-3, 1.55e-6], [18660e-12, 1e-3, 1.55e-6], [18670e-12, 2e-3, 1.55e-6], [18680e-12, 1e-3, 1.55e-6], [18690e-12, 2e-3, 1.55e-6], [18700e-12, 1e-3, 1.55e-6], [18710e-12, 2e-3, 1.55e-6], [18720e-12, 1e-3, 1.55e-6], [18730e-12, 2e-3, 1.55e-6], [18740e-12, 1e-3, 1.55e-6], [18750e-12, 2e-3, 1.55e-6], [18760e-12, 1e-3, 1.55e-6], [18770e-12, 2e-3, 1.55e-6], [18780e-12, 1e-3, 1.55e-6], [18790e-12, 2e-3, 1.55e-6], [18800e-12, 1e-3, 1.55e-6], [18810e-12, 2e-3, 1.55e-6], [18820e-12, 1e-3, 1.55e-6], [18830e-12, 2e-3, 1.55e-6], [18840e-12, 1e-3, 1.55e-6], [18850e-12, 2e-3, 1.55e-6], [18860e-12, 1e-3, 1.55e-6], [18870e-12, 2e-3, 1.55e-6], [18880e-12, 1e-3, 1.55e-6], [18890e-12, 2e-3, 1.55e-6], [18900e-12, 1e-3, 1.55e-6], [18910e-12, 2e-3, 1.55e-6], [18920e-12, 1e-3, 1.55e-6], [18930e-12, 2e-3, 1.55e-6], [18940e-12, 1e-3, 1.55e-6], [18950e-12, 2e-3, 1.55e-6], [18960e-12, 1e-3, 1.55e-6], [18970e-12, 2e-3, 1.55e-6], [18980e-12, 1e-3, 1.55e-6], [18990e-12, 2e-3, 1.55e-6], [19000e-12, 1e-3, 1.55e-6], [19010e-12, 2e-3, 1.55e-6], [19020e-12, 1e-3, 1.55e-6], [19030e-12, 2e-3, 1.55e-6], [19040e-12, 1e-3, 1.55e-6], [19050e-12, 2e-3, 1.55e-6], [19060e-12, 1e-3, 1.55e-6], [19070e-12, 2e-3, 1.55e-6], [19080e-12, 1e-3, 1.55e-6], [19090e-12, 2e-3, 1.55e-6], [19100e-12, 1e-3, 1.55e-6], [19110e-12, 2e-3, 1.55e-6], [19120e-12, 1e-3, 1.55e-6], [19130e-12, 2e-3, 1.55e-6], [19140e-12, 1e-3, 1.55e-6], [19150e-12, 2e-3, 1.55e-6], [19160e-12, 1e-3, 1.55e-6], [19170e-12, 2e-3, 1.55e-6], [19180e-12, 1e-3, 1.55e-6], [19190e-12, 2e-3, 1.55e-6], [19200e-12, 1e-3, 1.55e-6], [19210e-12, 2e-3, 1.55e-6], [19220e-12, 1e-3, 1.55e-6], [19230e-12, 2e-3, 1.55e-6], [19240e-12, 1e-3, 1.55e-6], [19250e-12, 2e-3, 1.55e-6], [19260e-12, 1e-3, 1.55e-6], [19270e-12, 2e-3, 1.55e-6], [19280e-12, 1e-3, 1.55e-6], [19290e-12, 2e-3, 1.55e-6], [19300e-12, 1e-3, 1.55e-6], [19310e-12, 2e-3, 1.55e-6], [19320e-12, 1e-3, 1.55e-6], [19330e-12, 2e-3, 1.55e-6], [19340e-12, 1e-3, 1.55e-6], [19350e-12, 2e-3, 1.55e-6], [19360e-12, 1e-3, 1.55e-6], [19370e-12, 2e-3, 1.55e-6], [19380e-12, 1e-3, 1.55e-6], [19390e-12, 2e-3, 1.55e-6], [19400e-12, 1e-3, 1.55e-6], [19410e-12, 2e-3, 1.55e-6], [19420e-12, 1e-3, 1.55e-6], [19430e-12, 2e-3, 1.55e-6], [19440e-12, 1e-3, 1.55e-6], [19450e-12, 2e-3, 1.55e-6], [19460e-12, 1e-3, 1.55e-6], [19470e-12, 2e-3, 1.55e-6], [19480e-12, 1e-3, 1.55e-6], [19490e-12, 2e-3, 1.55e-6], [19500e-12, 1e-3, 1.55e-6], [19510e-12, 2e-3, 1.55e-6], [19520e-12, 1e-3, 1.55e-6], [19530e-12, 2e-3, 1.55e-6], [19540e-12, 1e-3, 1.55e-6], [19550e-12, 2e-3, 1.55e-6], [19560e-12, 1e-3, 1.55e-6], [19570e-12, 2e-3, 1.55e-6], [19580e-12, 1e-3, 1.55e-6], [19590e-12, 2e-3, 1.55e-6], [19600e-12, 1e-3, 1.55e-6], [19610e-12, 2e-3, 1.55e-6], [19620e-12, 1e-3, 1.55e-6], [19630e-12, 2e-3, 1.55e-6], [19640e-12, 1e-3, 1.55e-6], [19650e-12, 2e-3, 1.55e-6], [19660e-12, 1e-3, 1.55e-6], [19670e-12, 2e-3, 1.55e-6], [19680e-12, 1e-3, 1.55e-6], [19690e-12, 2e-3, 1.55e-6], [19700e-12, 1e-3, 1.55e-6], [19710e-12, 2e-3, 1.55e-6], [19720e-12, 1e-3, 1.55e-6], [19730e-12, 2e-3, 1.55e-6], [19740e-12, 1e-3, 1.55e-6], [19750e-12, 2e-3, 1.55e-6], [19760e-12, 1e-3, 1.55e-6], [19770e-12, 2e-3, 1.55e-6], [19780e-12, 1e-3, 1.55e-6], [19790e-12, 2e-3, 1.55e-6], [19800e-12, 1e-3, 1.55e-6], [19810e-12, 2e-3, 1.55e-6], [19820e-12, 1e-3, 1.55e-6], [19830e-12, 2e-3, 1.55e-6], [19840e-12, 1e-3, 1.55e-6], [19850e-12, 2e-3, 1.55e-6], [19860e-12, 1e-3, 1.55e-6], [19870e-12, 2e-3, 1.55e-6], [19880e-12, 1e-3, 1.55e-6], [19890e-12, 2e-3, 1.55e-6], [19900e-12, 1e-3, 1.55e-6], [19910e-12, 2e-3, 1.55e-6], [19920e-12, 1e-3, 1.55e-6], [19930e-12, 2e-3, 1.55e-6], [19940e-12, 1e-3, 1.55e-6], [19950e-12, 2e-3, 1.55e-6], [19960e-12, 1e-3, 1.55e-6], [19970e-12, 2e-3, 1.55e-6], [19980e-12, 1e-3, 1.55e-6], [19990e-12, 2e-3, 1.55e-6]]
wg1 in out length=1e-4
probe1 out
.tran 20e-9
