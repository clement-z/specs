* B-186: an MLPROBE in a .dc wavelength sweep, next to a fixed 1.55 um source (backlog/repro/b186-mlprobe-dc-wavelength-sweep.cir).
* At each point MLPROBE1 records its three listed wavelengths: 1.548 um 0.5 mW then 0 (absent at point 2),
* 1.549 um 0 then 0.5 mW, 1.55 um 1 mW at both; PROBE1 the swept wavelength (PD5)
CWSRC1 a wl=1.548e-6 power=1e-3
CWSRC2 b wl=1.55e-6 power=2e-3
MERGER1 a b c
WG1 c d length=10u
PROBE1 d
MLPROBE1 d wl=[1.548e-6, 1.549e-6, 1.55e-6]
.dc WL(cwsrc1) 1.548e-6 1.549e-6 1e-9
