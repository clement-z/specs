* B-052: PCMCELL positional arguments are `emelt n tc ta` (4 allowed; a Debug
* build aborted on the 3rd one, assert(args.size() <= 2)).
* Model (PCMElement::update_transmission_local, nothing programs in an .op):
*   T(k) = tc + (ta - tc) * tanh(3 * k / n), out = T * P_in.
* Expected, P_in = 1 mW:
*   pcmcell1 (state k = 0):   T = tc = 0.85 -> ROOT/out = 0.000850 W (0.029155 sqrt(W))
*   pcmcell2 (k = n = 10):    T = 0.85 + 0.1 * tanh(3) = 0.949505
*                             -> ROOT/out2 = 0.000950 W (0.030814 sqrt(W)), so ta is read too
cwsrc1 in wl=1.55e-6 power=1e-3
pcmcell1 in out 1e-12 10 0.85 0.95
cwsrc2 in2 wl=1.55e-6 power=1e-3
pcmcell2 in2 out2 1e-12 10 0.85 0.95 k=10
.op
