* B-180: integer literals are 64-bit; one beyond 9223372036854775807 is a parse error (it was clamped to
* 2147483647 silently). Here a positional argument (CWSRC wl power phi).
* Expected: "Parsing error (tests/golden/netlists/b180-int-literal-positional.cir:6): integer literal
*   99999999999999999999 is out of range (the limit is 9223372036854775807)", then
*   -- while parsing line: "cwsrc1 a 1.55e-6 99999999999999999999", exit 1
cwsrc1 a 1.55e-6 99999999999999999999
probe1 a
.op
