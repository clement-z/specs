* B-153: invalid .options value (resolution=0.5) must be rejected
cwsrc1 a wl=1.55e-6 power=1e-3
wg1 a b length=1e-4
probe1 b
.options resolution=0.5
.tran 1e-11
