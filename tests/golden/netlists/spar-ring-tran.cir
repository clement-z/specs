* F-03: the exported add-drop ring as SPAR in .tran: a pulse at 1.55 um; delay=auto per path (PF03b): out
* follows the in->out path, whose negative group delay at the through-port null is replaced by 0 (one
* warning), drop the in->drop path's delay; --vci prints the device parameters
vlsrc1 in values=[[0, 0, 1.55e-6], [1e-12, 1, 1.55e-6], [20e-12, 0, 1.55e-6]]
spar1 in add out drop file="../../sparam/data/add_drop_ring.sparam"
.options timescale=-15
.save out drop
.tran 40e-12
