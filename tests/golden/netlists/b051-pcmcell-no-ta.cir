* B-051: PCMCELL requires tc and ta (no physical default; the C++ constructor
* defaults made such a cell fully opaque). Here ta is missing (tc given as the
* third positional argument).
* Expected: Error (ROOT/PCMCELL1): PCM Cell needs values for both Tc and Ta (missing: ta)
cwsrc1 in wl=1.55e-6 power=1e-3
pcmcell1 in out 1e-12 10 0.85
.op
