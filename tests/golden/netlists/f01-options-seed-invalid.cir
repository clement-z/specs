* F-01: .options seed must be an integer (netlist numbers are doubles: 0 to 2^53).
* Expected: "Error: .options: SEED must be an integer between 0 and 2^53 (got 1.5)", exit 1
pdet1 a v1 nb=0
.options seed=1.5
.tran 10e-12
