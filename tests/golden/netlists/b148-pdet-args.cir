* B-148: PDET with three positional arguments (at most 2)
cwsrc1 a wl=1.55e-6 power=1e-3
pdet1 a e 1e-12 1 3
.tran 1e-11
