* B-124: lossless all-pass ring, CW operating point, default reltol (1e-4): the event propagation stops when
* a change is below max(abstol, reltol * |last|), so the steady state is truncated. Compare with
* b124-allpass-ring-tight-reltol.cir (reltol = 1e-9). Same circuit as backlog/repro/a5-allpass-ring-op.cir.
* Exact: k = sqrt(0.15), t = r = sqrt(0.85) = 0.921954 (round-trip field transmission), on resonance
* (phi = 2 pi * 1 * 775 um / 1550 nm = 1000 pi): out = 1 W (phase pi), ring_br = ring_bl = k^2 / (1 - t)^2
* = 24.626059 W.
* Expected: out = 0.995098 W (-0.49 %), ring_br = ring_bl = 24.563207 W (-0.26 %). Error bound: the
* circulating field is short by reltol * r/(1 - r) .. reltol/(1 - r) = 11.8 .. 12.8 x reltol (here 12.8),
* amplified at the output by 2 (1 + t) = 3.84 on resonance (power): 45 .. 49 x reltol (here 49).
cwsrc1 in wl=1.55e-6 power=1
coupler1 in ring_bl out ring_br k=0.3872983346207417
wg_ring ring_br ring_bl length=775e-6 neff=1 ng=1 att=0
probe1 out
.options timescale=-13
.op
