* F-12: --param of a name that the netlist never assigns at root level: defined anyway (usable as
* {pin}), with one warning on stderr after parsing. Run with --param pin=2e-3:
* ROOT/a = 0.002 W; stderr: Warning: --param pin: the netlist has no .param pin
cwsrc1 a wl=1.55e-6 power={pin}
probe1 a
.op
