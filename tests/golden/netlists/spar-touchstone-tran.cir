* F-03: SPAR from Touchstone (engineering convention, conjugated on import) in .tran: pulses at two
* wavelengths leave SPAR and the WG of the same length at the same times (group delay L*ng/c rounded to the
* 100 fs time step) with the same fields
vlsrc1 in values=[[0, 0, 1.55e-6], [1e-12, 1, 1.55e-6], [3e-12, 0.3, 1.56e-6], [5e-12, 0.5, 1.55e-6], [9e-12, 0, 1.55e-6]]
splitter1 in a b
wg1 a out_wg length=100e-6 neff=2.2 ng=4.2 att=10
spar1 b out_spar file="../../sparam/fixtures/wg_v2.ts" format="touchstone"
mlprobe1 out_wg wl=[1.55e-6, 1.56e-6]
mlprobe2 out_spar wl=[1.55e-6, 1.56e-6]
.tran 20e-12
