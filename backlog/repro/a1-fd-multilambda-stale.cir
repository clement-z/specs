* F-A1-01: .op with two wavelengths converging on one merger output gives a stale value.
* Hand computation (merger: out = (in1+in2)/sqrt(2) per wavelength, fields in sqrt(W)):
*   u(1550) = 0.5/sqrt2 = 0.353553 ; v(1550) = 1/sqrt2 = 0.707107
*   m(1550) = (u+v)/sqrt2 = 0.750000 (0.5625 W)   <- expected
* Observed with the current engine: ROOT/m = 1550 nm 0.500000 (0.25 W) = v/sqrt2 (stale partial sum),
* also propagated to ROOT/o. Control: set cwsrc2/cwsrc4 to wl=1.55e-6 power=0 -> m = 0.75 (correct).
cwsrc1 a1 wl=1.55e-6 power=0.25
cwsrc2 a2 wl=1.56e-6 power=4
cwsrc3 b1 wl=1.55e-6 power=1
cwsrc4 b2 wl=1.56e-6 power=0.01
mergeru a1 a2 u
mergerv b1 b2 v
mergerm u v m
wg1 m o length=1e-6 neff=2.3 ng=4 att=0
.op
