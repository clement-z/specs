* V7: same as v4 with splitter listed first
splitter1 c z1 z2
cwsrc1 a wl=1.55e-6 power=1e-3
cwsrc2 b wl=1.55e-6 power=1e-3
crossing1 a b c& d
.op
