* A3 repro: VLSRC positional values file is silently ignored
* (parse_element.cpp:714 tests args.size() > 1 instead of > 0).
* Expected: emissions at 0.1/0.2/0.3 ns read from the file; observed: only the
* initial 0 at enable. Run from the directory containing a3-vl-noheader.csv.
* cwsrc0 only registers 1550 nm so that the OP printout does not abort with
* "Wavelength not found in global vector" (all nets would otherwise be id 0).
cwsrc0 dummy wl=1.55e-6 power=0
vlsrc1 in "a3-vl-noheader.csv"
.tran 1e-9
