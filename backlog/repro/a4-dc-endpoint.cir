* DC sweep: 1.5um to 1.6um by 10nm (SPICE: 11 points incl. endpoint)
cwsrc1 a wl=1.55e-6 power=1e-3
probe1 a
.dc /cwsrc1/WL 1.5e-6 1.6e-6 1e-8
