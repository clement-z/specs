* line 1
cwsrc1 a wl=1.55e-6 power=1e-3
wg1 a b lenght=1e-4
probe1 b
.tran 1e-11
